* NGSPICE file created from top_century_clock.ext - technology: sky130A

* Black-box entry subcircuit for sky130_fd_sc_hd__fill_2 abstract view
.subckt sky130_fd_sc_hd__fill_2 VGND VNB VPB VPWR
.ends

* Black-box entry subcircuit for sky130_fd_sc_hd__tapvpwrvgnd_1 abstract view
.subckt sky130_fd_sc_hd__tapvpwrvgnd_1 VGND VPWR
.ends

* Black-box entry subcircuit for sky130_fd_sc_hd__fill_1 abstract view
.subckt sky130_fd_sc_hd__fill_1 VGND VNB VPB VPWR
.ends

* Black-box entry subcircuit for sky130_fd_sc_hd__decap_6 abstract view
.subckt sky130_fd_sc_hd__decap_6 VGND VNB VPB VPWR
.ends

* Black-box entry subcircuit for sky130_ef_sc_hd__decap_12 abstract view
.subckt sky130_ef_sc_hd__decap_12 VPWR VGND VPB VNB
.ends

* Black-box entry subcircuit for sky130_fd_sc_hd__a21boi_1 abstract view
.subckt sky130_fd_sc_hd__a21boi_1 A1 A2 B1_N VGND VNB VPB VPWR Y
.ends

* Black-box entry subcircuit for sky130_fd_sc_hd__buf_2 abstract view
.subckt sky130_fd_sc_hd__buf_2 A VGND VNB VPB VPWR X
.ends

* Black-box entry subcircuit for sky130_fd_sc_hd__clkbuf_2 abstract view
.subckt sky130_fd_sc_hd__clkbuf_2 A VGND VNB VPB VPWR X
.ends

* Black-box entry subcircuit for sky130_fd_sc_hd__decap_3 abstract view
.subckt sky130_fd_sc_hd__decap_3 VGND VNB VPB VPWR
.ends

* Black-box entry subcircuit for sky130_fd_sc_hd__decap_8 abstract view
.subckt sky130_fd_sc_hd__decap_8 VGND VNB VPB VPWR
.ends

* Black-box entry subcircuit for sky130_fd_sc_hd__o21ba_1 abstract view
.subckt sky130_fd_sc_hd__o21ba_1 A1 A2 B1_N VGND VNB VPB VPWR X
.ends

* Black-box entry subcircuit for sky130_fd_sc_hd__dfrtp_1 abstract view
.subckt sky130_fd_sc_hd__dfrtp_1 CLK D RESET_B VGND VNB VPB VPWR Q
.ends

* Black-box entry subcircuit for sky130_fd_sc_hd__o21a_1 abstract view
.subckt sky130_fd_sc_hd__o21a_1 A1 A2 B1 VGND VNB VPB VPWR X
.ends

* Black-box entry subcircuit for sky130_fd_sc_hd__and3_1 abstract view
.subckt sky130_fd_sc_hd__and3_1 A B C VGND VNB VPB VPWR X
.ends

* Black-box entry subcircuit for sky130_fd_sc_hd__a211o_1 abstract view
.subckt sky130_fd_sc_hd__a211o_1 A1 A2 B1 C1 VGND VNB VPB VPWR X
.ends

* Black-box entry subcircuit for sky130_fd_sc_hd__nor2_1 abstract view
.subckt sky130_fd_sc_hd__nor2_1 A B VGND VNB VPB VPWR Y
.ends

* Black-box entry subcircuit for sky130_fd_sc_hd__buf_1 abstract view
.subckt sky130_fd_sc_hd__buf_1 A VGND VNB VPB VPWR X
.ends

* Black-box entry subcircuit for sky130_fd_sc_hd__and2_1 abstract view
.subckt sky130_fd_sc_hd__and2_1 A B VGND VNB VPB VPWR X
.ends

* Black-box entry subcircuit for sky130_fd_sc_hd__a22o_1 abstract view
.subckt sky130_fd_sc_hd__a22o_1 A1 A2 B1 B2 VGND VNB VPB VPWR X
.ends

* Black-box entry subcircuit for sky130_fd_sc_hd__nand2_1 abstract view
.subckt sky130_fd_sc_hd__nand2_1 A B VGND VNB VPB VPWR Y
.ends

* Black-box entry subcircuit for sky130_fd_sc_hd__or4_1 abstract view
.subckt sky130_fd_sc_hd__or4_1 A B C D VGND VNB VPB VPWR X
.ends

* Black-box entry subcircuit for sky130_fd_sc_hd__clkbuf_1 abstract view
.subckt sky130_fd_sc_hd__clkbuf_1 A VGND VNB VPB VPWR X
.ends

* Black-box entry subcircuit for sky130_fd_sc_hd__inv_2 abstract view
.subckt sky130_fd_sc_hd__inv_2 A VGND VNB VPB VPWR Y
.ends

* Black-box entry subcircuit for sky130_fd_sc_hd__mux2_1 abstract view
.subckt sky130_fd_sc_hd__mux2_1 A0 A1 S VGND VNB VPB VPWR X
.ends

* Black-box entry subcircuit for sky130_fd_sc_hd__nand2b_1 abstract view
.subckt sky130_fd_sc_hd__nand2b_1 A_N B VGND VNB VPB VPWR Y
.ends

* Black-box entry subcircuit for sky130_fd_sc_hd__clkbuf_16 abstract view
.subckt sky130_fd_sc_hd__clkbuf_16 A VGND VNB VPB VPWR X
.ends

* Black-box entry subcircuit for sky130_fd_sc_hd__a31o_1 abstract view
.subckt sky130_fd_sc_hd__a31o_1 A1 A2 A3 B1 VGND VNB VPB VPWR X
.ends

* Black-box entry subcircuit for sky130_fd_sc_hd__clkbuf_4 abstract view
.subckt sky130_fd_sc_hd__clkbuf_4 A VGND VNB VPB VPWR X
.ends

* Black-box entry subcircuit for sky130_fd_sc_hd__decap_4 abstract view
.subckt sky130_fd_sc_hd__decap_4 VGND VNB VPB VPWR
.ends

* Black-box entry subcircuit for sky130_fd_sc_hd__xor2_1 abstract view
.subckt sky130_fd_sc_hd__xor2_1 A B VGND VNB VPB VPWR X
.ends

* Black-box entry subcircuit for sky130_fd_sc_hd__xnor2_1 abstract view
.subckt sky130_fd_sc_hd__xnor2_1 A B VGND VNB VPB VPWR Y
.ends

* Black-box entry subcircuit for sky130_fd_sc_hd__and2b_1 abstract view
.subckt sky130_fd_sc_hd__and2b_1 A_N B VGND VNB VPB VPWR X
.ends

* Black-box entry subcircuit for sky130_fd_sc_hd__nor3_1 abstract view
.subckt sky130_fd_sc_hd__nor3_1 A B C VGND VNB VPB VPWR Y
.ends

* Black-box entry subcircuit for sky130_fd_sc_hd__dfrtp_2 abstract view
.subckt sky130_fd_sc_hd__dfrtp_2 CLK D RESET_B VGND VNB VPB VPWR Q
.ends

* Black-box entry subcircuit for sky130_fd_sc_hd__and3b_1 abstract view
.subckt sky130_fd_sc_hd__and3b_1 A_N B C VGND VNB VPB VPWR X
.ends

* Black-box entry subcircuit for sky130_fd_sc_hd__o31a_1 abstract view
.subckt sky130_fd_sc_hd__o31a_1 A1 A2 A3 B1 VGND VNB VPB VPWR X
.ends

* Black-box entry subcircuit for sky130_fd_sc_hd__or2_1 abstract view
.subckt sky130_fd_sc_hd__or2_1 A B VGND VNB VPB VPWR X
.ends

* Black-box entry subcircuit for sky130_fd_sc_hd__o31ai_1 abstract view
.subckt sky130_fd_sc_hd__o31ai_1 A1 A2 A3 B1 VGND VNB VPB VPWR Y
.ends

* Black-box entry subcircuit for sky130_fd_sc_hd__a21o_1 abstract view
.subckt sky130_fd_sc_hd__a21o_1 A1 A2 B1 VGND VNB VPB VPWR X
.ends

* Black-box entry subcircuit for sky130_fd_sc_hd__a21o_2 abstract view
.subckt sky130_fd_sc_hd__a21o_2 A1 A2 B1 VGND VNB VPB VPWR X
.ends

* Black-box entry subcircuit for sky130_fd_sc_hd__and4bb_1 abstract view
.subckt sky130_fd_sc_hd__and4bb_1 A_N B_N C D VGND VNB VPB VPWR X
.ends

* Black-box entry subcircuit for sky130_fd_sc_hd__dfstp_1 abstract view
.subckt sky130_fd_sc_hd__dfstp_1 CLK D SET_B VGND VNB VPB VPWR Q
.ends

* Black-box entry subcircuit for sky130_fd_sc_hd__dlygate4sd3_1 abstract view
.subckt sky130_fd_sc_hd__dlygate4sd3_1 A VGND VNB VPB VPWR X
.ends

* Black-box entry subcircuit for sky130_fd_sc_hd__o21ai_1 abstract view
.subckt sky130_fd_sc_hd__o21ai_1 A1 A2 B1 VGND VNB VPB VPWR Y
.ends

* Black-box entry subcircuit for sky130_fd_sc_hd__o22a_1 abstract view
.subckt sky130_fd_sc_hd__o22a_1 A1 A2 B1 B2 VGND VNB VPB VPWR X
.ends

* Black-box entry subcircuit for sky130_fd_sc_hd__dfrtp_4 abstract view
.subckt sky130_fd_sc_hd__dfrtp_4 CLK D RESET_B VGND VNB VPB VPWR Q
.ends

* Black-box entry subcircuit for sky130_fd_sc_hd__o21bai_1 abstract view
.subckt sky130_fd_sc_hd__o21bai_1 A1 A2 B1_N VGND VNB VPB VPWR Y
.ends

* Black-box entry subcircuit for sky130_fd_sc_hd__o211ai_4 abstract view
.subckt sky130_fd_sc_hd__o211ai_4 A1 A2 B1 C1 VGND VNB VPB VPWR Y
.ends

* Black-box entry subcircuit for sky130_fd_sc_hd__or4bb_1 abstract view
.subckt sky130_fd_sc_hd__or4bb_1 A B C_N D_N VGND VNB VPB VPWR X
.ends

* Black-box entry subcircuit for sky130_fd_sc_hd__or4b_2 abstract view
.subckt sky130_fd_sc_hd__or4b_2 A B C D_N VGND VNB VPB VPWR X
.ends

* Black-box entry subcircuit for sky130_fd_sc_hd__clkbuf_8 abstract view
.subckt sky130_fd_sc_hd__clkbuf_8 A VGND VNB VPB VPWR X
.ends

* Black-box entry subcircuit for sky130_fd_sc_hd__a21oi_1 abstract view
.subckt sky130_fd_sc_hd__a21oi_1 A1 A2 B1 VGND VNB VPB VPWR Y
.ends

* Black-box entry subcircuit for sky130_fd_sc_hd__a41o_1 abstract view
.subckt sky130_fd_sc_hd__a41o_1 A1 A2 A3 A4 B1 VGND VNB VPB VPWR X
.ends

* Black-box entry subcircuit for sky130_fd_sc_hd__and4_1 abstract view
.subckt sky130_fd_sc_hd__and4_1 A B C D VGND VNB VPB VPWR X
.ends

* Black-box entry subcircuit for sky130_fd_sc_hd__a32o_1 abstract view
.subckt sky130_fd_sc_hd__a32o_1 A1 A2 A3 B1 B2 VGND VNB VPB VPWR X
.ends

* Black-box entry subcircuit for sky130_fd_sc_hd__clkinv_2 abstract view
.subckt sky130_fd_sc_hd__clkinv_2 A VGND VNB VPB VPWR Y
.ends

* Black-box entry subcircuit for sky130_fd_sc_hd__o2bb2a_1 abstract view
.subckt sky130_fd_sc_hd__o2bb2a_1 A1_N A2_N B1 B2 VGND VNB VPB VPWR X
.ends

* Black-box entry subcircuit for sky130_fd_sc_hd__conb_1 abstract view
.subckt sky130_fd_sc_hd__conb_1 VGND VNB VPB VPWR HI LO
.ends

* Black-box entry subcircuit for sky130_fd_sc_hd__clkinv_4 abstract view
.subckt sky130_fd_sc_hd__clkinv_4 A VGND VNB VPB VPWR Y
.ends

* Black-box entry subcircuit for sky130_fd_sc_hd__dfstp_2 abstract view
.subckt sky130_fd_sc_hd__dfstp_2 CLK D SET_B VGND VNB VPB VPWR Q
.ends

* Black-box entry subcircuit for sky130_fd_sc_hd__or3_1 abstract view
.subckt sky130_fd_sc_hd__or3_1 A B C VGND VNB VPB VPWR X
.ends

* Black-box entry subcircuit for sky130_fd_sc_hd__a2bb2o_1 abstract view
.subckt sky130_fd_sc_hd__a2bb2o_1 A1_N A2_N B1 B2 VGND VNB VPB VPWR X
.ends

* Black-box entry subcircuit for sky130_fd_sc_hd__clkinvlp_4 abstract view
.subckt sky130_fd_sc_hd__clkinvlp_4 A VGND VNB VPB VPWR Y
.ends

* Black-box entry subcircuit for sky130_fd_sc_hd__o32a_1 abstract view
.subckt sky130_fd_sc_hd__o32a_1 A1 A2 A3 B1 B2 VGND VNB VPB VPWR X
.ends

* Black-box entry subcircuit for sky130_fd_sc_hd__a21bo_1 abstract view
.subckt sky130_fd_sc_hd__a21bo_1 A1 A2 B1_N VGND VNB VPB VPWR X
.ends

* Black-box entry subcircuit for sky130_fd_sc_hd__nor2_2 abstract view
.subckt sky130_fd_sc_hd__nor2_2 A B VGND VNB VPB VPWR Y
.ends

* Black-box entry subcircuit for sky130_fd_sc_hd__or2_2 abstract view
.subckt sky130_fd_sc_hd__or2_2 A B VGND VNB VPB VPWR X
.ends

* Black-box entry subcircuit for sky130_fd_sc_hd__or3b_1 abstract view
.subckt sky130_fd_sc_hd__or3b_1 A B C_N VGND VNB VPB VPWR X
.ends

* Black-box entry subcircuit for sky130_fd_sc_hd__nand3_1 abstract view
.subckt sky130_fd_sc_hd__nand3_1 A B C VGND VNB VPB VPWR Y
.ends

* Black-box entry subcircuit for sky130_fd_sc_hd__o2bb2a_2 abstract view
.subckt sky130_fd_sc_hd__o2bb2a_2 A1_N A2_N B1 B2 VGND VNB VPB VPWR X
.ends

* Black-box entry subcircuit for sky130_fd_sc_hd__o211a_1 abstract view
.subckt sky130_fd_sc_hd__o211a_1 A1 A2 B1 C1 VGND VNB VPB VPWR X
.ends

* Black-box entry subcircuit for sky130_fd_sc_hd__or4b_1 abstract view
.subckt sky130_fd_sc_hd__or4b_1 A B C D_N VGND VNB VPB VPWR X
.ends

* Black-box entry subcircuit for sky130_fd_sc_hd__o22ai_1 abstract view
.subckt sky130_fd_sc_hd__o22ai_1 A1 A2 B1 B2 VGND VNB VPB VPWR Y
.ends

* Black-box entry subcircuit for sky130_fd_sc_hd__nand3b_1 abstract view
.subckt sky130_fd_sc_hd__nand3b_1 A_N B C VGND VNB VPB VPWR Y
.ends

* Black-box entry subcircuit for sky130_fd_sc_hd__a21oi_4 abstract view
.subckt sky130_fd_sc_hd__a21oi_4 A1 A2 B1 VGND VNB VPB VPWR Y
.ends

* Black-box entry subcircuit for sky130_fd_sc_hd__a21bo_2 abstract view
.subckt sky130_fd_sc_hd__a21bo_2 A1 A2 B1_N VGND VNB VPB VPWR X
.ends

* Black-box entry subcircuit for sky130_fd_sc_hd__a211oi_2 abstract view
.subckt sky130_fd_sc_hd__a211oi_2 A1 A2 B1 C1 VGND VNB VPB VPWR Y
.ends

* Black-box entry subcircuit for sky130_fd_sc_hd__a22oi_1 abstract view
.subckt sky130_fd_sc_hd__a22oi_1 A1 A2 B1 B2 VGND VNB VPB VPWR Y
.ends

* Black-box entry subcircuit for sky130_fd_sc_hd__and3b_2 abstract view
.subckt sky130_fd_sc_hd__and3b_2 A_N B C VGND VNB VPB VPWR X
.ends

* Black-box entry subcircuit for sky130_fd_sc_hd__nand3b_2 abstract view
.subckt sky130_fd_sc_hd__nand3b_2 A_N B C VGND VNB VPB VPWR Y
.ends

* Black-box entry subcircuit for sky130_fd_sc_hd__a21oi_2 abstract view
.subckt sky130_fd_sc_hd__a21oi_2 A1 A2 B1 VGND VNB VPB VPWR Y
.ends

* Black-box entry subcircuit for sky130_fd_sc_hd__and4_2 abstract view
.subckt sky130_fd_sc_hd__and4_2 A B C D VGND VNB VPB VPWR X
.ends

* Black-box entry subcircuit for sky130_fd_sc_hd__a221o_1 abstract view
.subckt sky130_fd_sc_hd__a221o_1 A1 A2 B1 B2 C1 VGND VNB VPB VPWR X
.ends

* Black-box entry subcircuit for sky130_fd_sc_hd__a2bb2oi_1 abstract view
.subckt sky130_fd_sc_hd__a2bb2oi_1 A1_N A2_N B1 B2 VGND VNB VPB VPWR Y
.ends

* Black-box entry subcircuit for sky130_fd_sc_hd__and4b_1 abstract view
.subckt sky130_fd_sc_hd__and4b_1 A_N B C D VGND VNB VPB VPWR X
.ends

* Black-box entry subcircuit for sky130_fd_sc_hd__o211ai_1 abstract view
.subckt sky130_fd_sc_hd__o211ai_1 A1 A2 B1 C1 VGND VNB VPB VPWR Y
.ends

* Black-box entry subcircuit for sky130_fd_sc_hd__nand4_1 abstract view
.subckt sky130_fd_sc_hd__nand4_1 A B C D VGND VNB VPB VPWR Y
.ends

* Black-box entry subcircuit for sky130_fd_sc_hd__o311a_1 abstract view
.subckt sky130_fd_sc_hd__o311a_1 A1 A2 A3 B1 C1 VGND VNB VPB VPWR X
.ends

* Black-box entry subcircuit for sky130_fd_sc_hd__o2bb2ai_2 abstract view
.subckt sky130_fd_sc_hd__o2bb2ai_2 A1_N A2_N B1 B2 VGND VNB VPB VPWR Y
.ends

* Black-box entry subcircuit for sky130_fd_sc_hd__nor3b_1 abstract view
.subckt sky130_fd_sc_hd__nor3b_1 A B C_N VGND VNB VPB VPWR Y
.ends

* Black-box entry subcircuit for sky130_fd_sc_hd__nor4_1 abstract view
.subckt sky130_fd_sc_hd__nor4_1 A B C D VGND VNB VPB VPWR Y
.ends

* Black-box entry subcircuit for sky130_fd_sc_hd__a221oi_1 abstract view
.subckt sky130_fd_sc_hd__a221oi_1 A1 A2 B1 B2 C1 VGND VNB VPB VPWR Y
.ends

* Black-box entry subcircuit for sky130_fd_sc_hd__a311oi_1 abstract view
.subckt sky130_fd_sc_hd__a311oi_1 A1 A2 A3 B1 C1 VGND VNB VPB VPWR Y
.ends

* Black-box entry subcircuit for sky130_fd_sc_hd__o21ai_2 abstract view
.subckt sky130_fd_sc_hd__o21ai_2 A1 A2 B1 VGND VNB VPB VPWR Y
.ends

* Black-box entry subcircuit for sky130_fd_sc_hd__nor3_2 abstract view
.subckt sky130_fd_sc_hd__nor3_2 A B C VGND VNB VPB VPWR Y
.ends

.subckt top_century_clock VGND VPWR alarm clk inc led_am_pm[0] led_am_pm[1] led_am_pm[2]
+ led_am_pm[3] led_am_pm[4] led_am_pm[5] led_am_pm[6] led_hun_y[0] led_hun_y[1] led_hun_y[2]
+ led_hun_y[3] led_hun_y[4] led_hun_y[5] led_hun_y[6] led_ten_d[0] led_ten_d[1] led_ten_d[2]
+ led_ten_d[3] led_ten_d[4] led_ten_d[5] led_ten_d[6] led_ten_h[0] led_ten_h[1] led_ten_h[2]
+ led_ten_h[3] led_ten_h[4] led_ten_h[5] led_ten_h[6] led_ten_m[0] led_ten_m[1] led_ten_m[2]
+ led_ten_m[3] led_ten_m[4] led_ten_m[5] led_ten_m[6] led_ten_mo[0] led_ten_mo[1]
+ led_ten_mo[2] led_ten_mo[3] led_ten_mo[4] led_ten_mo[5] led_ten_mo[6] led_ten_s[0]
+ led_ten_s[1] led_ten_s[2] led_ten_s[3] led_ten_s[4] led_ten_s[5] led_ten_s[6] led_ten_y[0]
+ led_ten_y[1] led_ten_y[2] led_ten_y[3] led_ten_y[4] led_ten_y[5] led_ten_y[6] led_thou_y[0]
+ led_thou_y[1] led_thou_y[2] led_thou_y[3] led_thou_y[4] led_thou_y[5] led_thou_y[6]
+ led_unit_d[0] led_unit_d[1] led_unit_d[2] led_unit_d[3] led_unit_d[4] led_unit_d[5]
+ led_unit_d[6] led_unit_h[0] led_unit_h[1] led_unit_h[2] led_unit_h[3] led_unit_h[4]
+ led_unit_h[5] led_unit_h[6] led_unit_m[0] led_unit_m[1] led_unit_m[2] led_unit_m[3]
+ led_unit_m[4] led_unit_m[5] led_unit_m[6] led_unit_mo[0] led_unit_mo[1] led_unit_mo[2]
+ led_unit_mo[3] led_unit_mo[4] led_unit_mo[5] led_unit_mo[6] led_unit_s[0] led_unit_s[1]
+ led_unit_s[2] led_unit_s[3] led_unit_s[4] led_unit_s[5] led_unit_s[6] led_unit_y[0]
+ led_unit_y[1] led_unit_y[2] led_unit_y[3] led_unit_y[4] led_unit_y[5] led_unit_y[6]
+ mode reset_n sel
XFILLER_39_222 VGND VGND VPWR VPWR sky130_fd_sc_hd__fill_2
XTAP_TAPCELL_ROW_17_191 VGND VPWR sky130_fd_sc_hd__tapvpwrvgnd_1
XFILLER_45_236 VGND VGND VPWR VPWR sky130_fd_sc_hd__fill_1
XFILLER_26_85 VGND VGND VPWR VPWR sky130_fd_sc_hd__decap_6
XFILLER_9_137 VPWR VGND VPWR VGND sky130_ef_sc_hd__decap_12
XFILLER_13_155 VPWR VGND VPWR VGND sky130_ef_sc_hd__decap_12
X_0985_ net102 _0422_ _0421_ VGND VGND VPWR VPWR _0015_ sky130_fd_sc_hd__a21boi_1
Xfanout116 top_counter.min_counter.u2 VGND VGND VPWR VPWR net116 sky130_fd_sc_hd__buf_2
Xfanout138 net145 VGND VGND VPWR VPWR net138 sky130_fd_sc_hd__clkbuf_2
Xfanout105 net106 VGND VGND VPWR VPWR net105 sky130_fd_sc_hd__clkbuf_2
Xfanout127 top_counter.day_in_month_decode.unit_mo\[0\] VGND VGND VPWR VPWR net127
+ sky130_fd_sc_hd__buf_2
XFILLER_42_217 VGND VGND VPWR VPWR sky130_fd_sc_hd__decap_3
XFILLER_12_76 VGND VGND VPWR VPWR sky130_fd_sc_hd__decap_8
XFILLER_37_84 VGND VGND VPWR VPWR sky130_fd_sc_hd__fill_1
XFILLER_37_40 VPWR VGND VPWR VGND sky130_ef_sc_hd__decap_12
XFILLER_18_236 VGND VGND VPWR VPWR sky130_fd_sc_hd__fill_2
XFILLER_33_217 VGND VGND VPWR VPWR sky130_fd_sc_hd__decap_6
XFILLER_18_269 VGND VGND VPWR VPWR sky130_fd_sc_hd__decap_3
XFILLER_5_162 VGND VGND VPWR VPWR sky130_fd_sc_hd__fill_2
X_0770_ net115 top_counter.min_counter.t2 _0274_ VGND VGND VPWR VPWR _0275_ sky130_fd_sc_hd__o21ba_1
XTAP_TAPCELL_ROW_11_164 VGND VPWR sky130_fd_sc_hd__tapvpwrvgnd_1
X_1184_ clknet_3_0__leaf_clk _0045_ net136 VGND VGND VPWR VPWR ten_s\[1\] sky130_fd_sc_hd__dfrtp_1
X_0968_ _0403_ _0406_ net102 VGND VGND VPWR VPWR _0413_ sky130_fd_sc_hd__o21a_1
XTAP_TAPCELL_ROW_34_278 VGND VPWR sky130_fd_sc_hd__tapvpwrvgnd_1
X_0899_ top_counter.min_counter.c0 top_counter.min_counter.u3 _0192_ VGND VGND VPWR
+ VPWR _0358_ sky130_fd_sc_hd__and3_1
XFILLER_30_209 VPWR VGND VPWR VGND sky130_ef_sc_hd__decap_12
XTAP_TAPCELL_ROW_25_234 VGND VPWR sky130_fd_sc_hd__tapvpwrvgnd_1
XTAP_TAPCELL_ROW_48_348 VGND VPWR sky130_fd_sc_hd__tapvpwrvgnd_1
XFILLER_48_83 VGND VGND VPWR VPWR sky130_fd_sc_hd__fill_1
XFILLER_0_35 VGND VGND VPWR VPWR sky130_fd_sc_hd__decap_3
X_0822_ hun_y\[3\] _0305_ hun_y\[2\] VGND VGND VPWR VPWR net16 sky130_fd_sc_hd__o21a_1
XFILLER_14_294 VGND VGND VPWR VPWR sky130_fd_sc_hd__fill_2
X_0753_ hour_counter_alarm.ten_h_alarm\[3\] net105 _0251_ _0072_ VGND VGND VPWR VPWR
+ _0264_ sky130_fd_sc_hd__a211o_1
X_0684_ _0208_ net103 VGND VGND VPWR VPWR _0210_ sky130_fd_sc_hd__nor2_1
XTAP_TAPCELL_ROW_39_304 VGND VPWR sky130_fd_sc_hd__tapvpwrvgnd_1
X_1098_ min_counter_alarm.unit_m_alarm\[0\] min_counter_alarm.unit_m_alarm\[1\] min_counter_alarm.unit_m_alarm\[2\]
+ VGND VGND VPWR VPWR _0496_ sky130_fd_sc_hd__and3_1
XTAP_TAPCELL_ROW_22_215 VGND VPWR sky130_fd_sc_hd__tapvpwrvgnd_1
X_1167_ clknet_3_6__leaf_clk _0035_ net144 VGND VGND VPWR VPWR top_counter.hour_counter.unit_h\[3\]
+ sky130_fd_sc_hd__dfrtp_1
XFILLER_20_253 VPWR VGND VPWR VGND sky130_ef_sc_hd__decap_12
XFILLER_20_275 VGND VGND VPWR VPWR sky130_fd_sc_hd__fill_2
XPHY_EDGE_ROW_8_Left_58 VGND VGND VPWR VPWR sky130_fd_sc_hd__decap_3
XFILLER_34_85 VGND VGND VPWR VPWR sky130_fd_sc_hd__fill_1
XFILLER_7_202 VGND VGND VPWR VPWR sky130_fd_sc_hd__fill_1
XFILLER_11_231 VGND VGND VPWR VPWR sky130_fd_sc_hd__decap_3
Xwire111 _0098_ VGND VGND VPWR VPWR net111 sky130_fd_sc_hd__buf_1
XFILLER_38_139 VGND VGND VPWR VPWR sky130_fd_sc_hd__fill_1
XFILLER_22_7 VPWR VGND VPWR VGND sky130_ef_sc_hd__decap_12
X_1021_ min_counter_alarm.ten_m_alarm\[0\] min_counter_alarm.ten_m_alarm\[1\] VGND
+ VGND VPWR VPWR _0445_ sky130_fd_sc_hd__and2_1
X_0805_ hun_y\[0\] hun_y\[1\] VGND VGND VPWR VPWR _0295_ sky130_fd_sc_hd__and2_1
X_0736_ net120 _0238_ _0246_ _0237_ VGND VGND VPWR VPWR net66 sky130_fd_sc_hd__a22o_1
X_0667_ net116 _0191_ VGND VGND VPWR VPWR _0199_ sky130_fd_sc_hd__nand2_1
X_0598_ _0143_ _0149_ _0150_ _0151_ VGND VGND VPWR VPWR _0152_ sky130_fd_sc_hd__or4_1
XFILLER_44_109 VPWR VGND VPWR VGND sky130_ef_sc_hd__decap_12
X_1219_ net10 VGND VGND VPWR VPWR net6 sky130_fd_sc_hd__clkbuf_1
XFILLER_4_238 VGND VGND VPWR VPWR sky130_fd_sc_hd__fill_1
XFILLER_29_30 VPWR VGND VPWR VGND sky130_ef_sc_hd__decap_12
XFILLER_43_153 VPWR VGND VPWR VGND sky130_ef_sc_hd__decap_12
XTAP_TAPCELL_ROW_41_310 VGND VPWR sky130_fd_sc_hd__tapvpwrvgnd_1
XFILLER_3_293 VGND VGND VPWR VPWR sky130_fd_sc_hd__decap_3
X_0521_ hour_counter_alarm.unit_h_alarm\[2\] VGND VGND VPWR VPWR _0076_ sky130_fd_sc_hd__inv_2
XFILLER_13_3 VPWR VGND VPWR VGND sky130_ef_sc_hd__decap_12
X_1004_ _0370_ _0395_ net122 VGND VGND VPWR VPWR _0024_ sky130_fd_sc_hd__mux2_1
XFILLER_34_197 VPWR VGND VPWR VGND sky130_ef_sc_hd__decap_12
XFILLER_34_153 VPWR VGND VPWR VGND sky130_ef_sc_hd__decap_12
X_0719_ top_counter.day_counter.unit_d\[2\] net119 VGND VGND VPWR VPWR _0237_ sky130_fd_sc_hd__nand2b_1
XFILLER_25_120 VPWR VGND VPWR VGND sky130_ef_sc_hd__decap_12
XFILLER_31_31 VPWR VGND VPWR VGND sky130_ef_sc_hd__decap_12
XFILLER_15_98 VGND VGND VPWR VPWR sky130_fd_sc_hd__fill_2
Xoutput53 net53 VGND VGND VPWR VPWR led_ten_y[0] sky130_fd_sc_hd__buf_2
Xoutput64 net64 VGND VGND VPWR VPWR led_unit_d[4] sky130_fd_sc_hd__buf_2
Xoutput20 net20 VGND VGND VPWR VPWR led_ten_d[2] sky130_fd_sc_hd__buf_2
Xoutput42 net42 VGND VGND VPWR VPWR led_ten_mo[3] sky130_fd_sc_hd__buf_2
XFILLER_31_97 VPWR VGND VPWR VGND sky130_ef_sc_hd__decap_12
XFILLER_0_230 VPWR VGND VPWR VGND sky130_ef_sc_hd__decap_12
Xoutput7 net7 VGND VGND VPWR VPWR led_am_pm[1] sky130_fd_sc_hd__buf_1
Xoutput75 net75 VGND VGND VPWR VPWR led_unit_m[1] sky130_fd_sc_hd__buf_2
Xoutput31 net31 VGND VGND VPWR VPWR led_ten_h[6] sky130_fd_sc_hd__buf_2
Xoutput97 net97 VGND VGND VPWR VPWR led_unit_y[2] sky130_fd_sc_hd__buf_2
XFILLER_48_289 VGND VGND VPWR VPWR sky130_fd_sc_hd__decap_6
Xoutput86 net86 VGND VGND VPWR VPWR led_unit_mo[5] sky130_fd_sc_hd__buf_2
XFILLER_31_167 VGND VGND VPWR VPWR sky130_fd_sc_hd__fill_1
XFILLER_39_289 VGND VGND VPWR VPWR sky130_fd_sc_hd__decap_3
XTAP_TAPCELL_ROW_17_192 VGND VPWR sky130_fd_sc_hd__tapvpwrvgnd_1
XPHY_EDGE_ROW_37_Left_87 VGND VGND VPWR VPWR sky130_fd_sc_hd__decap_3
Xclkbuf_3_6__f_clk clknet_0_clk VGND VGND VPWR VPWR clknet_3_6__leaf_clk sky130_fd_sc_hd__clkbuf_16
XFILLER_13_145 VGND VGND VPWR VPWR sky130_fd_sc_hd__fill_1
XFILLER_13_167 VGND VGND VPWR VPWR sky130_fd_sc_hd__fill_1
XFILLER_26_64 VGND VGND VPWR VPWR sky130_fd_sc_hd__fill_1
XFILLER_42_41 VPWR VGND VPWR VGND sky130_ef_sc_hd__decap_12
XFILLER_9_149 VPWR VGND VPWR VGND sky130_ef_sc_hd__decap_12
XFILLER_3_35 VGND VGND VPWR VPWR sky130_fd_sc_hd__fill_1
X_0984_ net129 net128 _0166_ _0403_ VGND VGND VPWR VPWR _0422_ sky130_fd_sc_hd__a31o_1
Xfanout128 top_counter.leap_year_check.u\[3\] VGND VGND VPWR VPWR net128 sky130_fd_sc_hd__buf_2
Xfanout117 top_counter.min_counter.ct0 VGND VGND VPWR VPWR net117 sky130_fd_sc_hd__clkbuf_2
Xfanout139 net145 VGND VGND VPWR VPWR net139 sky130_fd_sc_hd__clkbuf_4
Xfanout106 net107 VGND VGND VPWR VPWR net106 sky130_fd_sc_hd__clkbuf_2
XFILLER_35_281 VGND VGND VPWR VPWR sky130_fd_sc_hd__decap_8
XTAP_TAPCELL_ROW_5_130 VGND VPWR sky130_fd_sc_hd__tapvpwrvgnd_1
XFILLER_37_52 VGND VGND VPWR VPWR sky130_fd_sc_hd__decap_4
XFILLER_26_281 VGND VGND VPWR VPWR sky130_fd_sc_hd__decap_8
X_1183_ clknet_3_0__leaf_clk _0044_ net136 VGND VGND VPWR VPWR ten_s\[0\] sky130_fd_sc_hd__dfrtp_1
X_0967_ hun_y\[3\] _0412_ VGND VGND VPWR VPWR _0007_ sky130_fd_sc_hd__xor2_1
XTAP_TAPCELL_ROW_34_279 VGND VPWR sky130_fd_sc_hd__tapvpwrvgnd_1
XFILLER_32_273 VGND VGND VPWR VPWR sky130_fd_sc_hd__fill_1
XFILLER_32_251 VGND VGND VPWR VPWR sky130_fd_sc_hd__fill_1
X_0898_ _0079_ _0357_ VGND VGND VPWR VPWR top_counter.min_counter.d_u0 sky130_fd_sc_hd__xnor2_1
XPHY_EDGE_ROW_12_Right_12 VGND VGND VPWR VPWR sky130_fd_sc_hd__decap_3
XPHY_EDGE_ROW_21_Right_21 VGND VGND VPWR VPWR sky130_fd_sc_hd__decap_3
XPHY_EDGE_ROW_30_Right_30 VGND VGND VPWR VPWR sky130_fd_sc_hd__decap_3
XFILLER_2_122 VGND VGND VPWR VPWR sky130_fd_sc_hd__decap_6
XTAP_TAPCELL_ROW_48_349 VGND VPWR sky130_fd_sc_hd__tapvpwrvgnd_1
X_0821_ _0293_ _0301_ VGND VGND VPWR VPWR _0305_ sky130_fd_sc_hd__nand2_1
XFILLER_14_262 VGND VGND VPWR VPWR sky130_fd_sc_hd__decap_6
XFILLER_14_251 VGND VGND VPWR VPWR sky130_fd_sc_hd__fill_1
X_0752_ _0255_ _0252_ VGND VGND VPWR VPWR _0263_ sky130_fd_sc_hd__and2b_1
XFILLER_43_3 VPWR VGND VPWR VGND sky130_ef_sc_hd__decap_12
XPHY_EDGE_ROW_24_Left_74 VGND VGND VPWR VPWR sky130_fd_sc_hd__decap_3
X_0683_ net118 net106 _0207_ VGND VGND VPWR VPWR _0209_ sky130_fd_sc_hd__nor3_1
X_1166_ clknet_3_6__leaf_clk _0034_ net144 VGND VGND VPWR VPWR top_counter.hour_counter.unit_h\[2\]
+ sky130_fd_sc_hd__dfrtp_2
X_1097_ net104 _0495_ VGND VGND VPWR VPWR _0054_ sky130_fd_sc_hd__nor2_1
XTAP_TAPCELL_ROW_22_216 VGND VPWR sky130_fd_sc_hd__tapvpwrvgnd_1
XFILLER_20_265 VGND VGND VPWR VPWR sky130_fd_sc_hd__decap_4
XFILLER_34_53 VGND VGND VPWR VPWR sky130_fd_sc_hd__decap_8
XFILLER_7_225 VPWR VGND VPWR VGND sky130_ef_sc_hd__decap_12
XFILLER_11_254 VGND VGND VPWR VPWR sky130_fd_sc_hd__decap_3
X_1020_ net5 _0439_ _0443_ VGND VGND VPWR VPWR _0444_ sky130_fd_sc_hd__and3b_1
XFILLER_15_7 VGND VGND VPWR VPWR sky130_fd_sc_hd__decap_6
XFILLER_46_195 VGND VGND VPWR VPWR sky130_fd_sc_hd__fill_1
X_0735_ net119 _0235_ _0242_ net120 VGND VGND VPWR VPWR net65 sky130_fd_sc_hd__o31a_1
X_0804_ _0096_ _0293_ VGND VGND VPWR VPWR _0294_ sky130_fd_sc_hd__nand2_1
X_0666_ top_counter.min_counter.c0 top_counter.min_counter.u1 VGND VGND VPWR VPWR
+ _0198_ sky130_fd_sc_hd__or2_1
X_0597_ _0103_ _0105_ _0110_ _0128_ VGND VGND VPWR VPWR _0151_ sky130_fd_sc_hd__or4_1
X_1149_ clknet_3_4__leaf_clk _0017_ net142 VGND VGND VPWR VPWR top_counter.day_in_month_decode.unit_mo\[1\]
+ sky130_fd_sc_hd__dfrtp_1
XFILLER_29_42 VGND VGND VPWR VPWR sky130_fd_sc_hd__decap_8
XFILLER_29_53 VGND VGND VPWR VPWR sky130_fd_sc_hd__decap_3
XFILLER_43_165 VGND VGND VPWR VPWR sky130_fd_sc_hd__decap_3
XTAP_TAPCELL_ROW_41_311 VGND VPWR sky130_fd_sc_hd__tapvpwrvgnd_1
XFILLER_28_195 VGND VGND VPWR VPWR sky130_fd_sc_hd__fill_1
X_0520_ hour_counter_alarm.unit_h_alarm\[1\] VGND VGND VPWR VPWR _0075_ sky130_fd_sc_hd__inv_2
X_1003_ ten_mo\[3\] _0431_ VGND VGND VPWR VPWR _0023_ sky130_fd_sc_hd__xor2_1
XFILLER_19_140 VPWR VGND VPWR VGND sky130_ef_sc_hd__decap_12
XFILLER_34_165 VPWR VGND VPWR VGND sky130_ef_sc_hd__decap_12
X_0718_ net121 net119 net120 _0236_ VGND VGND VPWR VPWR net60 sky130_fd_sc_hd__o31ai_1
XPHY_EDGE_ROW_6_Right_6 VGND VGND VPWR VPWR sky130_fd_sc_hd__decap_3
X_0649_ _0089_ net126 _0182_ _0185_ VGND VGND VPWR VPWR _0186_ sky130_fd_sc_hd__o31ai_1
XPHY_EDGE_ROW_11_Left_61 VGND VGND VPWR VPWR sky130_fd_sc_hd__decap_3
XFILLER_15_22 VGND VGND VPWR VPWR sky130_fd_sc_hd__fill_1
XFILLER_15_66 VPWR VGND VPWR VGND sky130_ef_sc_hd__decap_12
XFILLER_25_132 VPWR VGND VPWR VGND sky130_ef_sc_hd__decap_12
XFILLER_31_76 VGND VGND VPWR VPWR sky130_fd_sc_hd__fill_1
XFILLER_31_43 VGND VGND VPWR VPWR sky130_fd_sc_hd__decap_8
Xoutput54 net54 VGND VGND VPWR VPWR led_ten_y[1] sky130_fd_sc_hd__buf_2
Xoutput65 net65 VGND VGND VPWR VPWR led_unit_d[5] sky130_fd_sc_hd__buf_2
Xoutput21 net21 VGND VGND VPWR VPWR led_ten_d[3] sky130_fd_sc_hd__buf_2
Xoutput43 net43 VGND VGND VPWR VPWR led_ten_mo[4] sky130_fd_sc_hd__buf_2
Xoutput98 net98 VGND VGND VPWR VPWR led_unit_y[3] sky130_fd_sc_hd__buf_2
XFILLER_0_253 VPWR VGND VPWR VGND sky130_ef_sc_hd__decap_12
XFILLER_0_242 VGND VGND VPWR VPWR sky130_fd_sc_hd__decap_8
Xoutput8 net8 VGND VGND VPWR VPWR led_am_pm[2] sky130_fd_sc_hd__buf_1
Xoutput32 net32 VGND VGND VPWR VPWR led_ten_m[0] sky130_fd_sc_hd__buf_2
Xoutput76 net76 VGND VGND VPWR VPWR led_unit_m[2] sky130_fd_sc_hd__buf_2
Xoutput10 net10 VGND VGND VPWR VPWR led_am_pm[6] sky130_fd_sc_hd__buf_1
Xoutput87 net87 VGND VGND VPWR VPWR led_unit_mo[6] sky130_fd_sc_hd__buf_2
XFILLER_31_113 VPWR VGND VPWR VGND sky130_ef_sc_hd__decap_12
XFILLER_39_257 VPWR VGND VPWR VGND sky130_ef_sc_hd__decap_12
XFILLER_39_279 VGND VGND VPWR VPWR sky130_fd_sc_hd__fill_1
XTAP_TAPCELL_ROW_17_193 VGND VPWR sky130_fd_sc_hd__tapvpwrvgnd_1
XFILLER_42_53 VGND VGND VPWR VPWR sky130_fd_sc_hd__fill_2
XFILLER_9_106 VGND VGND VPWR VPWR sky130_fd_sc_hd__decap_6
XFILLER_13_113 VPWR VGND VPWR VGND sky130_ef_sc_hd__decap_12
XFILLER_44_260 VGND VGND VPWR VPWR sky130_fd_sc_hd__decap_6
X_0983_ _0176_ net102 net128 VGND VGND VPWR VPWR _0421_ sky130_fd_sc_hd__a21o_1
Xfanout129 top_counter.leap_year_check.u\[2\] VGND VGND VPWR VPWR net129 sky130_fd_sc_hd__clkbuf_2
Xfanout107 _0153_ VGND VGND VPWR VPWR net107 sky130_fd_sc_hd__clkbuf_2
Xfanout118 top_counter.hour_counter.unit_h\[1\] VGND VGND VPWR VPWR net118 sky130_fd_sc_hd__buf_2
XFILLER_6_109 VGND VGND VPWR VPWR sky130_fd_sc_hd__decap_8
XTAP_TAPCELL_ROW_5_131 VGND VPWR sky130_fd_sc_hd__tapvpwrvgnd_1
XFILLER_18_249 VGND VGND VPWR VPWR sky130_fd_sc_hd__decap_3
X_1182_ clknet_3_1__leaf_clk _0043_ net137 VGND VGND VPWR VPWR top_counter.second_counter.unit_s\[3\]
+ sky130_fd_sc_hd__dfrtp_2
XTAP_TAPCELL_ROW_19_200 VGND VPWR sky130_fd_sc_hd__tapvpwrvgnd_1
XFILLER_17_271 VGND VGND VPWR VPWR sky130_fd_sc_hd__decap_8
XFILLER_17_293 VGND VGND VPWR VPWR sky130_fd_sc_hd__decap_3
XFILLER_24_219 VGND VGND VPWR VPWR sky130_fd_sc_hd__decap_8
X_0966_ _0303_ _0409_ _0411_ VGND VGND VPWR VPWR _0006_ sky130_fd_sc_hd__o21a_1
X_0897_ net1 control_unit.select_time\[1\] _0356_ VGND VGND VPWR VPWR _0357_ sky130_fd_sc_hd__a21o_2
XFILLER_23_55 VGND VGND VPWR VPWR sky130_fd_sc_hd__fill_1
XFILLER_3_3 VPWR VGND VPWR VGND sky130_ef_sc_hd__decap_12
XFILLER_48_41 VPWR VGND VPWR VGND sky130_ef_sc_hd__decap_12
XFILLER_0_15 VPWR VGND VPWR VGND sky130_ef_sc_hd__decap_12
XFILLER_9_35 VGND VGND VPWR VPWR sky130_fd_sc_hd__decap_3
XFILLER_14_274 VPWR VGND VPWR VGND sky130_ef_sc_hd__decap_12
X_0820_ hun_y\[3\] hun_y\[2\] _0293_ _0304_ VGND VGND VPWR VPWR net15 sky130_fd_sc_hd__o31ai_1
XFILLER_9_57 VGND VGND VPWR VPWR sky130_fd_sc_hd__fill_2
X_0751_ _0256_ _0262_ VGND VGND VPWR VPWR net25 sky130_fd_sc_hd__xor2_1
X_0682_ net105 _0207_ net118 VGND VGND VPWR VPWR _0208_ sky130_fd_sc_hd__o21a_1
XFILLER_49_182 VGND VGND VPWR VPWR sky130_fd_sc_hd__decap_3
X_1096_ min_counter_alarm.unit_m_alarm\[2\] _0494_ VGND VGND VPWR VPWR _0495_ sky130_fd_sc_hd__xnor2_1
X_1165_ clknet_3_6__leaf_clk _0033_ net144 VGND VGND VPWR VPWR top_counter.hour_counter.unit_h\[1\]
+ sky130_fd_sc_hd__dfrtp_1
XTAP_TAPCELL_ROW_22_217 VGND VPWR sky130_fd_sc_hd__tapvpwrvgnd_1
X_0949_ control_unit.select_time\[2\] control_unit.select_time\[3\] _0368_ _0369_
+ VGND VGND VPWR VPWR _0398_ sky130_fd_sc_hd__and4bb_1
XPHY_EDGE_ROW_41_Left_91 VGND VGND VPWR VPWR sky130_fd_sc_hd__decap_3
XFILLER_7_237 VGND VGND VPWR VPWR sky130_fd_sc_hd__decap_6
XFILLER_46_141 VPWR VGND VPWR VGND sky130_ef_sc_hd__decap_12
X_0734_ net119 _0247_ _0248_ VGND VGND VPWR VPWR net64 sky130_fd_sc_hd__o21a_1
X_0803_ _0095_ hun_y\[1\] VGND VGND VPWR VPWR _0293_ sky130_fd_sc_hd__nand2_1
X_0665_ top_counter.min_counter.c0 top_counter.min_counter.u1 VGND VGND VPWR VPWR
+ _0197_ sky130_fd_sc_hd__nor2_1
X_0596_ _0109_ _0126_ _0132_ _0133_ VGND VGND VPWR VPWR _0150_ sky130_fd_sc_hd__or4_1
X_1079_ net106 _0481_ VGND VGND VPWR VPWR _0484_ sky130_fd_sc_hd__nor2_1
X_1148_ clknet_3_4__leaf_clk _0016_ net142 VGND VGND VPWR VPWR top_counter.day_in_month_decode.unit_mo\[0\]
+ sky130_fd_sc_hd__dfstp_1
XFILLER_20_34 VPWR VGND VPWR VGND sky130_ef_sc_hd__decap_12
Xhold10 control_unit.select_time\[3\] VGND VGND VPWR VPWR net164 sky130_fd_sc_hd__dlygate4sd3_1
XFILLER_28_141 VPWR VGND VPWR VGND sky130_ef_sc_hd__decap_12
XTAP_TAPCELL_ROW_41_312 VGND VPWR sky130_fd_sc_hd__tapvpwrvgnd_1
XFILLER_6_47 VGND VGND VPWR VPWR sky130_fd_sc_hd__fill_1
X_1002_ _0431_ _0432_ VGND VGND VPWR VPWR _0022_ sky130_fd_sc_hd__and2b_1
XFILLER_34_111 VPWR VGND VPWR VGND sky130_ef_sc_hd__decap_12
XFILLER_19_152 VGND VGND VPWR VPWR sky130_fd_sc_hd__decap_8
XFILLER_19_185 VGND VGND VPWR VPWR sky130_fd_sc_hd__fill_2
XFILLER_34_177 VPWR VGND VPWR VGND sky130_ef_sc_hd__decap_12
X_0717_ top_counter.day_counter.unit_d\[2\] _0235_ _0234_ VGND VGND VPWR VPWR _0236_
+ sky130_fd_sc_hd__o21ai_1
X_0648_ net125 net124 VGND VGND VPWR VPWR _0185_ sky130_fd_sc_hd__nand2_1
X_0579_ top_counter.min_counter.u2 min_counter_alarm.unit_m_alarm\[2\] VGND VGND VPWR
+ VPWR _0134_ sky130_fd_sc_hd__and2b_1
XFILLER_15_45 VGND VGND VPWR VPWR sky130_fd_sc_hd__decap_3
XFILLER_15_78 VPWR VGND VPWR VGND sky130_ef_sc_hd__decap_12
XFILLER_25_144 VPWR VGND VPWR VGND sky130_ef_sc_hd__decap_12
XFILLER_25_177 VGND VGND VPWR VPWR sky130_fd_sc_hd__fill_2
XFILLER_25_199 VPWR VGND VPWR VGND sky130_ef_sc_hd__decap_12
Xoutput99 net99 VGND VGND VPWR VPWR led_unit_y[4] sky130_fd_sc_hd__buf_2
Xoutput55 net55 VGND VGND VPWR VPWR led_ten_y[2] sky130_fd_sc_hd__buf_2
Xoutput66 net66 VGND VGND VPWR VPWR led_unit_d[6] sky130_fd_sc_hd__buf_2
Xoutput22 net22 VGND VGND VPWR VPWR led_ten_d[4] sky130_fd_sc_hd__buf_2
Xoutput11 net11 VGND VGND VPWR VPWR led_hun_y[0] sky130_fd_sc_hd__buf_2
Xoutput44 net44 VGND VGND VPWR VPWR led_ten_mo[5] sky130_fd_sc_hd__buf_2
XFILLER_0_265 VPWR VGND VPWR VGND sky130_ef_sc_hd__decap_12
Xoutput9 net9 VGND VGND VPWR VPWR led_am_pm[5] sky130_fd_sc_hd__buf_1
Xoutput77 net77 VGND VGND VPWR VPWR led_unit_m[3] sky130_fd_sc_hd__buf_2
Xoutput33 net33 VGND VGND VPWR VPWR led_ten_m[1] sky130_fd_sc_hd__buf_2
Xoutput88 net88 VGND VGND VPWR VPWR led_unit_s[0] sky130_fd_sc_hd__buf_2
XFILLER_31_169 VPWR VGND VPWR VGND sky130_ef_sc_hd__decap_12
XFILLER_31_125 VPWR VGND VPWR VGND sky130_ef_sc_hd__decap_12
XFILLER_39_269 VGND VGND VPWR VPWR sky130_fd_sc_hd__decap_6
XFILLER_39_225 VPWR VGND VPWR VGND sky130_ef_sc_hd__decap_12
XTAP_TAPCELL_ROW_17_194 VGND VPWR sky130_fd_sc_hd__tapvpwrvgnd_1
XFILLER_13_125 VPWR VGND VPWR VGND sky130_ef_sc_hd__decap_12
XFILLER_13_169 VPWR VGND VPWR VGND sky130_ef_sc_hd__decap_12
XFILLER_26_99 VPWR VGND VPWR VGND sky130_ef_sc_hd__decap_12
XFILLER_3_15 VPWR VGND VPWR VGND sky130_ef_sc_hd__decap_12
X_0982_ top_counter.leap_year_check.u\[2\] net102 _0406_ _0420_ VGND VGND VPWR VPWR
+ _0014_ sky130_fd_sc_hd__o22a_1
XTAP_TAPCELL_ROW_14_175 VGND VPWR sky130_fd_sc_hd__tapvpwrvgnd_1
Xfanout119 top_counter.day_counter.unit_d\[3\] VGND VGND VPWR VPWR net119 sky130_fd_sc_hd__buf_2
XFILLER_42_209 VGND VGND VPWR VPWR sky130_fd_sc_hd__decap_8
XFILLER_35_261 VGND VGND VPWR VPWR sky130_fd_sc_hd__decap_8
XFILLER_10_117 VGND VGND VPWR VPWR sky130_fd_sc_hd__decap_3
XTAP_TAPCELL_ROW_5_132 VGND VPWR sky130_fd_sc_hd__tapvpwrvgnd_1
XFILLER_26_261 VGND VGND VPWR VPWR sky130_fd_sc_hd__decap_3
XTAP_TAPCELL_ROW_28_245 VGND VPWR sky130_fd_sc_hd__tapvpwrvgnd_1
X_1181_ clknet_3_0__leaf_clk _0042_ net136 VGND VGND VPWR VPWR top_counter.second_counter.unit_s\[2\]
+ sky130_fd_sc_hd__dfrtp_4
XTAP_TAPCELL_ROW_19_201 VGND VPWR sky130_fd_sc_hd__tapvpwrvgnd_1
XFILLER_24_209 VGND VGND VPWR VPWR sky130_fd_sc_hd__decap_4
XFILLER_32_253 VPWR VGND VPWR VGND sky130_ef_sc_hd__decap_12
X_0965_ _0303_ net102 _0408_ VGND VGND VPWR VPWR _0412_ sky130_fd_sc_hd__and3b_1
X_0896_ _0353_ _0354_ _0355_ VGND VGND VPWR VPWR _0356_ sky130_fd_sc_hd__nor3_1
XTAP_TAPCELL_ROW_33_270 VGND VPWR sky130_fd_sc_hd__tapvpwrvgnd_1
XFILLER_48_53 VGND VGND VPWR VPWR sky130_fd_sc_hd__decap_4
XFILLER_0_27 VGND VGND VPWR VPWR sky130_fd_sc_hd__fill_1
XFILLER_0_49 VGND VGND VPWR VPWR sky130_fd_sc_hd__decap_3
XFILLER_14_253 VGND VGND VPWR VPWR sky130_fd_sc_hd__fill_1
XFILLER_14_286 VGND VGND VPWR VPWR sky130_fd_sc_hd__decap_8
X_0750_ _0260_ _0261_ VGND VGND VPWR VPWR _0262_ sky130_fd_sc_hd__and2_1
X_0681_ top_counter.hour_counter.unit_h\[0\] _0206_ VGND VGND VPWR VPWR _0207_ sky130_fd_sc_hd__or2_1
XFILLER_49_161 VGND VGND VPWR VPWR sky130_fd_sc_hd__decap_3
XTAP_TAPCELL_ROW_47_340 VGND VPWR sky130_fd_sc_hd__tapvpwrvgnd_1
X_1095_ _0438_ _0492_ VGND VGND VPWR VPWR _0494_ sky130_fd_sc_hd__nor2_1
X_1164_ clknet_3_6__leaf_clk _0032_ net144 VGND VGND VPWR VPWR top_counter.hour_counter.unit_h\[0\]
+ sky130_fd_sc_hd__dfrtp_2
X_0948_ net132 _0397_ VGND VGND VPWR VPWR _0003_ sky130_fd_sc_hd__xnor2_1
XTAP_TAPCELL_ROW_22_218 VGND VPWR sky130_fd_sc_hd__tapvpwrvgnd_1
X_0879_ net133 _0343_ net132 VGND VGND VPWR VPWR _0345_ sky130_fd_sc_hd__o21bai_1
XFILLER_18_45 VGND VGND VPWR VPWR sky130_fd_sc_hd__fill_1
XFILLER_11_223 VGND VGND VPWR VPWR sky130_fd_sc_hd__fill_1
XFILLER_34_99 VPWR VGND VPWR VGND sky130_ef_sc_hd__decap_12
XFILLER_11_278 VGND VGND VPWR VPWR sky130_fd_sc_hd__fill_2
XFILLER_46_197 VGND VGND VPWR VPWR sky130_fd_sc_hd__fill_2
XFILLER_46_153 VGND VGND VPWR VPWR sky130_fd_sc_hd__fill_2
X_0802_ net110 _0205_ control_unit.mode_display\[1\] _0097_ VGND VGND VPWR VPWR net10
+ sky130_fd_sc_hd__o211ai_4
X_0733_ _0240_ _0247_ VGND VGND VPWR VPWR _0248_ sky130_fd_sc_hd__nand2_1
X_0664_ net116 top_counter.min_counter.u3 VGND VGND VPWR VPWR _0196_ sky130_fd_sc_hd__nand2_1
X_0595_ _0116_ _0121_ _0127_ _0129_ VGND VGND VPWR VPWR _0149_ sky130_fd_sc_hd__or4_1
X_1147_ clknet_3_7__leaf_clk _0015_ net141 VGND VGND VPWR VPWR top_counter.leap_year_check.u\[3\]
+ sky130_fd_sc_hd__dfrtp_1
XFILLER_1_70 VPWR VGND VPWR VGND sky130_ef_sc_hd__decap_12
X_1078_ _0481_ _0482_ _0477_ VGND VGND VPWR VPWR _0483_ sky130_fd_sc_hd__o21a_1
Xhold11 top_counter.second_counter.unit_s\[3\] VGND VGND VPWR VPWR net165 sky130_fd_sc_hd__dlygate4sd3_1
XFILLER_20_46 VPWR VGND VPWR VGND sky130_ef_sc_hd__decap_12
XFILLER_28_153 VPWR VGND VPWR VGND sky130_ef_sc_hd__decap_12
XFILLER_28_197 VGND VGND VPWR VPWR sky130_fd_sc_hd__fill_1
XFILLER_29_99 VPWR VGND VPWR VGND sky130_ef_sc_hd__decap_12
XFILLER_43_189 VPWR VGND VPWR VGND sky130_ef_sc_hd__decap_12
XTAP_TAPCELL_ROW_41_313 VGND VPWR sky130_fd_sc_hd__tapvpwrvgnd_1
XFILLER_6_15 VPWR VGND VPWR VGND sky130_ef_sc_hd__decap_12
XFILLER_20_7 VGND VGND VPWR VPWR sky130_fd_sc_hd__decap_3
X_1001_ _0281_ _0423_ _0425_ ten_mo\[2\] VGND VGND VPWR VPWR _0432_ sky130_fd_sc_hd__a31o_1
XFILLER_34_189 VGND VGND VPWR VPWR sky130_fd_sc_hd__decap_6
XFILLER_34_123 VPWR VGND VPWR VGND sky130_ef_sc_hd__decap_12
XFILLER_19_197 VPWR VGND VPWR VGND sky130_ef_sc_hd__decap_12
X_0716_ net122 net121 VGND VGND VPWR VPWR _0235_ sky130_fd_sc_hd__and2b_1
X_0578_ hour_counter_alarm.unit_h_alarm\[1\] net118 VGND VGND VPWR VPWR _0133_ sky130_fd_sc_hd__and2b_1
X_0647_ net125 _0183_ _0184_ net127 VGND VGND VPWR VPWR net83 sky130_fd_sc_hd__a22o_1
XFILLER_40_104 VGND VGND VPWR VPWR sky130_fd_sc_hd__fill_1
XFILLER_15_13 VGND VGND VPWR VPWR sky130_fd_sc_hd__fill_1
XFILLER_25_156 VPWR VGND VPWR VGND sky130_ef_sc_hd__decap_12
Xoutput23 net23 VGND VGND VPWR VPWR led_ten_d[5] sky130_fd_sc_hd__buf_2
Xoutput12 net12 VGND VGND VPWR VPWR led_hun_y[1] sky130_fd_sc_hd__buf_2
Xoutput34 net34 VGND VGND VPWR VPWR led_ten_m[2] sky130_fd_sc_hd__buf_2
Xoutput56 net56 VGND VGND VPWR VPWR led_ten_y[3] sky130_fd_sc_hd__buf_2
Xoutput67 net67 VGND VGND VPWR VPWR led_unit_h[0] sky130_fd_sc_hd__buf_2
Xoutput45 net45 VGND VGND VPWR VPWR led_ten_mo[6] sky130_fd_sc_hd__buf_2
XFILLER_0_277 VGND VGND VPWR VPWR sky130_fd_sc_hd__decap_3
Xoutput78 net78 VGND VGND VPWR VPWR led_unit_m[4] sky130_fd_sc_hd__buf_2
Xoutput89 net89 VGND VGND VPWR VPWR led_unit_s[1] sky130_fd_sc_hd__buf_2
XFILLER_16_101 VPWR VGND VPWR VGND sky130_ef_sc_hd__decap_12
XFILLER_31_137 VPWR VGND VPWR VGND sky130_ef_sc_hd__decap_12
XFILLER_47_281 VPWR VGND VPWR VGND sky130_ef_sc_hd__decap_12
XFILLER_39_237 VGND VGND VPWR VPWR sky130_fd_sc_hd__decap_6
XFILLER_11_3 VPWR VGND VPWR VGND sky130_ef_sc_hd__decap_12
XFILLER_38_270 VGND VGND VPWR VPWR sky130_fd_sc_hd__fill_2
XFILLER_13_137 VGND VGND VPWR VPWR sky130_fd_sc_hd__decap_8
XFILLER_3_27 VGND VGND VPWR VPWR sky130_fd_sc_hd__fill_1
X_0981_ _0176_ net102 _0177_ VGND VGND VPWR VPWR _0420_ sky130_fd_sc_hd__a21boi_1
XFILLER_44_251 VGND VGND VPWR VPWR sky130_fd_sc_hd__fill_1
XFILLER_8_141 VPWR VGND VPWR VGND sky130_ef_sc_hd__decap_12
XFILLER_12_181 VPWR VGND VPWR VGND sky130_ef_sc_hd__decap_12
XTAP_TAPCELL_ROW_14_176 VGND VPWR sky130_fd_sc_hd__tapvpwrvgnd_1
XTAP_TAPCELL_ROW_5_133 VGND VPWR sky130_fd_sc_hd__tapvpwrvgnd_1
XFILLER_37_99 VGND VGND VPWR VPWR sky130_fd_sc_hd__decap_3
XTAP_TAPCELL_ROW_28_246 VGND VPWR sky130_fd_sc_hd__tapvpwrvgnd_1
X_1180_ clknet_3_1__leaf_clk _0041_ net137 VGND VGND VPWR VPWR top_counter.second_counter.unit_s\[1\]
+ sky130_fd_sc_hd__dfrtp_2
XTAP_TAPCELL_ROW_19_202 VGND VPWR sky130_fd_sc_hd__tapvpwrvgnd_1
X_0964_ _0295_ net102 _0408_ hun_y\[2\] VGND VGND VPWR VPWR _0411_ sky130_fd_sc_hd__a31o_1
XFILLER_32_265 VGND VGND VPWR VPWR sky130_fd_sc_hd__decap_8
XFILLER_32_221 VPWR VGND VPWR VGND sky130_ef_sc_hd__decap_12
X_0895_ top_counter.second_counter.unit_s\[1\] top_counter.second_counter.unit_s\[2\]
+ top_counter.second_counter.unit_s\[3\] top_counter.second_counter.unit_s\[0\] VGND
+ VGND VPWR VPWR _0355_ sky130_fd_sc_hd__or4bb_1
XFILLER_23_221 VGND VGND VPWR VPWR sky130_fd_sc_hd__decap_3
XTAP_TAPCELL_ROW_33_271 VGND VPWR sky130_fd_sc_hd__tapvpwrvgnd_1
XFILLER_23_57 VPWR VGND VPWR VGND sky130_ef_sc_hd__decap_12
XFILLER_2_114 VGND VGND VPWR VPWR sky130_fd_sc_hd__fill_2
XFILLER_9_15 VPWR VGND VPWR VGND sky130_ef_sc_hd__decap_12
XFILLER_13_90 VGND VGND VPWR VPWR sky130_fd_sc_hd__fill_1
X_0680_ control_unit.mode_display\[0\] net111 _0205_ control_unit.mode_display\[1\]
+ VGND VGND VPWR VPWR _0206_ sky130_fd_sc_hd__or4b_2
XFILLER_1_180 VGND VGND VPWR VPWR sky130_fd_sc_hd__fill_2
XTAP_TAPCELL_ROW_47_341 VGND VPWR sky130_fd_sc_hd__tapvpwrvgnd_1
X_1163_ clknet_3_2__leaf_clk _0031_ net139 VGND VGND VPWR VPWR min_counter_alarm.ten_m_alarm\[3\]
+ sky130_fd_sc_hd__dfrtp_1
X_1094_ min_counter_alarm.unit_m_alarm\[0\] min_counter_alarm.unit_m_alarm\[1\] _0493_
+ VGND VGND VPWR VPWR _0053_ sky130_fd_sc_hd__o21a_1
X_0947_ _0338_ _0394_ VGND VGND VPWR VPWR _0397_ sky130_fd_sc_hd__or2_1
XFILLER_9_291 VGND VGND VPWR VPWR sky130_fd_sc_hd__fill_2
XTAP_TAPCELL_ROW_22_219 VGND VPWR sky130_fd_sc_hd__tapvpwrvgnd_1
X_0878_ _0336_ _0343_ VGND VGND VPWR VPWR _0344_ sky130_fd_sc_hd__or2_1
Xclkload0 clknet_3_0__leaf_clk VGND VGND VPWR VPWR clkload0/X sky130_fd_sc_hd__clkbuf_8
XPHY_EDGE_ROW_28_Left_78 VGND VGND VPWR VPWR sky130_fd_sc_hd__decap_3
X_0801_ _0093_ _0285_ _0290_ VGND VGND VPWR VPWR net45 sky130_fd_sc_hd__o21ai_1
X_0732_ net122 net121 net120 VGND VGND VPWR VPWR _0247_ sky130_fd_sc_hd__a21oi_1
XFILLER_41_3 VPWR VGND VPWR VGND sky130_ef_sc_hd__decap_12
X_0663_ _0081_ _0082_ VGND VGND VPWR VPWR _0195_ sky130_fd_sc_hd__nor2_1
X_0594_ min_counter_alarm.ten_m_alarm\[3\] net111 _0114_ _0118_ VGND VGND VPWR VPWR
+ _0148_ sky130_fd_sc_hd__or4_1
X_1146_ clknet_3_7__leaf_clk _0014_ net143 VGND VGND VPWR VPWR top_counter.leap_year_check.u\[2\]
+ sky130_fd_sc_hd__dfstp_1
XFILLER_1_82 VPWR VGND VPWR VGND sky130_ef_sc_hd__decap_12
XFILLER_37_198 VPWR VGND VPWR VGND sky130_ef_sc_hd__decap_12
X_1077_ hour_counter_alarm.unit_h_alarm\[0\] _0075_ _0076_ hour_counter_alarm.unit_h_alarm\[3\]
+ net106 VGND VGND VPWR VPWR _0482_ sky130_fd_sc_hd__a41o_1
XFILLER_4_209 VGND VGND VPWR VPWR sky130_fd_sc_hd__decap_6
XFILLER_20_25 VGND VGND VPWR VPWR sky130_fd_sc_hd__decap_3
XFILLER_20_58 VPWR VGND VPWR VGND sky130_ef_sc_hd__decap_12
Xhold12 min_counter_alarm.unit_m_alarm\[3\] VGND VGND VPWR VPWR net166 sky130_fd_sc_hd__dlygate4sd3_1
XFILLER_45_88 VPWR VGND VPWR VGND sky130_ef_sc_hd__decap_12
XFILLER_43_102 VGND VGND VPWR VPWR sky130_fd_sc_hd__fill_1
XFILLER_28_165 VPWR VGND VPWR VGND sky130_ef_sc_hd__decap_12
XTAP_TAPCELL_ROW_41_314 VGND VPWR sky130_fd_sc_hd__tapvpwrvgnd_1
XFILLER_6_27 VGND VGND VPWR VPWR sky130_fd_sc_hd__fill_1
XFILLER_3_253 VPWR VGND VPWR VGND sky130_ef_sc_hd__decap_12
X_1000_ ten_mo\[2\] _0281_ _0423_ _0425_ VGND VGND VPWR VPWR _0431_ sky130_fd_sc_hd__and4_1
XFILLER_19_121 VGND VGND VPWR VPWR sky130_fd_sc_hd__decap_8
XFILLER_34_135 VGND VGND VPWR VPWR sky130_fd_sc_hd__decap_4
X_0715_ net122 top_counter.day_counter.unit_d\[1\] top_counter.day_counter.unit_d\[3\]
+ VGND VGND VPWR VPWR _0234_ sky130_fd_sc_hd__a21o_1
X_0577_ top_counter.hour_counter.unit_h\[2\] hour_counter_alarm.unit_h_alarm\[2\]
+ VGND VGND VPWR VPWR _0132_ sky130_fd_sc_hd__and2b_1
X_0646_ net126 net124 VGND VGND VPWR VPWR _0184_ sky130_fd_sc_hd__nand2_1
X_1129_ control_unit.current_state\[0\] control_unit.current_state\[1\] VGND VGND
+ VPWR VPWR _0514_ sky130_fd_sc_hd__xnor2_1
Xoutput57 net57 VGND VGND VPWR VPWR led_ten_y[4] sky130_fd_sc_hd__buf_2
Xoutput24 net24 VGND VGND VPWR VPWR led_ten_d[6] sky130_fd_sc_hd__buf_2
Xoutput13 net13 VGND VGND VPWR VPWR led_hun_y[2] sky130_fd_sc_hd__buf_2
Xoutput46 net46 VGND VGND VPWR VPWR led_ten_s[0] sky130_fd_sc_hd__buf_2
Xoutput35 net35 VGND VGND VPWR VPWR led_ten_m[3] sky130_fd_sc_hd__buf_2
XFILLER_48_249 VGND VGND VPWR VPWR sky130_fd_sc_hd__decap_3
Xoutput68 net68 VGND VGND VPWR VPWR led_unit_h[1] sky130_fd_sc_hd__buf_2
XFILLER_0_223 VGND VGND VPWR VPWR sky130_fd_sc_hd__fill_1
Xoutput79 net79 VGND VGND VPWR VPWR led_unit_m[5] sky130_fd_sc_hd__buf_2
XFILLER_31_149 VPWR VGND VPWR VGND sky130_ef_sc_hd__decap_12
XFILLER_16_113 VGND VGND VPWR VPWR sky130_fd_sc_hd__fill_2
XPHY_EDGE_ROW_19_Right_19 VGND VGND VPWR VPWR sky130_fd_sc_hd__decap_3
Xclkbuf_3_1__f_clk clknet_0_clk VGND VGND VPWR VPWR clknet_3_1__leaf_clk sky130_fd_sc_hd__clkbuf_16
XPHY_EDGE_ROW_28_Right_28 VGND VGND VPWR VPWR sky130_fd_sc_hd__decap_3
XPHY_EDGE_ROW_37_Right_37 VGND VGND VPWR VPWR sky130_fd_sc_hd__decap_3
XPHY_EDGE_ROW_46_Right_46 VGND VGND VPWR VPWR sky130_fd_sc_hd__decap_3
XFILLER_7_70 VPWR VGND VPWR VGND sky130_ef_sc_hd__decap_12
XPHY_EDGE_ROW_15_Left_65 VGND VGND VPWR VPWR sky130_fd_sc_hd__decap_3
X_0629_ top_counter.leap_year_check.u\[0\] _0172_ _0173_ net129 VGND VGND VPWR VPWR
+ net97 sky130_fd_sc_hd__a22o_1
XFILLER_38_260 VGND VGND VPWR VPWR sky130_fd_sc_hd__decap_6
XFILLER_26_13 VGND VGND VPWR VPWR sky130_fd_sc_hd__fill_1
XFILLER_42_89 VPWR VGND VPWR VGND sky130_ef_sc_hd__decap_12
XFILLER_44_274 VPWR VGND VPWR VGND sky130_ef_sc_hd__decap_12
X_0980_ top_counter.leap_year_check.u\[1\] _0419_ net102 VGND VGND VPWR VPWR _0013_
+ sky130_fd_sc_hd__mux2_1
XTAP_TAPCELL_ROW_14_177 VGND VPWR sky130_fd_sc_hd__tapvpwrvgnd_1
XFILLER_8_153 VPWR VGND VPWR VGND sky130_ef_sc_hd__decap_12
XFILLER_12_193 VGND VGND VPWR VPWR sky130_fd_sc_hd__decap_3
XFILLER_27_208 VGND VGND VPWR VPWR sky130_fd_sc_hd__fill_1
XFILLER_12_15 VPWR VGND VPWR VGND sky130_ef_sc_hd__decap_12
XFILLER_37_23 VPWR VGND VPWR VGND sky130_ef_sc_hd__decap_12
XTAP_TAPCELL_ROW_5_134 VGND VPWR sky130_fd_sc_hd__tapvpwrvgnd_1
XFILLER_26_230 VGND VGND VPWR VPWR sky130_fd_sc_hd__decap_3
XTAP_TAPCELL_ROW_28_247 VGND VPWR sky130_fd_sc_hd__tapvpwrvgnd_1
XFILLER_41_222 VGND VGND VPWR VPWR sky130_fd_sc_hd__fill_2
XFILLER_5_167 VGND VGND VPWR VPWR sky130_fd_sc_hd__fill_1
XTAP_TAPCELL_ROW_19_203 VGND VPWR sky130_fd_sc_hd__tapvpwrvgnd_1
X_0963_ hun_y\[1\] _0409_ _0410_ VGND VGND VPWR VPWR _0005_ sky130_fd_sc_hd__a21o_1
XFILLER_32_233 VPWR VGND VPWR VGND sky130_ef_sc_hd__decap_12
X_0894_ control_unit.select_time\[0\] control_unit.select_time\[1\] VGND VGND VPWR
+ VPWR _0354_ sky130_fd_sc_hd__or2_1
XTAP_TAPCELL_ROW_2_115 VGND VPWR sky130_fd_sc_hd__tapvpwrvgnd_1
XTAP_TAPCELL_ROW_33_272 VGND VPWR sky130_fd_sc_hd__tapvpwrvgnd_1
XFILLER_23_69 VGND VGND VPWR VPWR sky130_fd_sc_hd__decap_6
XFILLER_48_66 VGND VGND VPWR VPWR sky130_fd_sc_hd__fill_1
XFILLER_48_88 VPWR VGND VPWR VGND sky130_ef_sc_hd__decap_12
XFILLER_0_29 VGND VGND VPWR VPWR sky130_fd_sc_hd__fill_2
XFILLER_9_27 VGND VGND VPWR VPWR sky130_fd_sc_hd__decap_8
XFILLER_49_141 VGND VGND VPWR VPWR sky130_fd_sc_hd__fill_2
X_1162_ clknet_3_2__leaf_clk _0030_ net139 VGND VGND VPWR VPWR min_counter_alarm.ten_m_alarm\[2\]
+ sky130_fd_sc_hd__dfrtp_1
XTAP_TAPCELL_ROW_47_342 VGND VPWR sky130_fd_sc_hd__tapvpwrvgnd_1
X_1093_ _0437_ _0441_ _0492_ _0491_ min_counter_alarm.unit_m_alarm\[1\] VGND VGND
+ VPWR VPWR _0493_ sky130_fd_sc_hd__a32o_1
X_0877_ _0094_ net135 VGND VGND VPWR VPWR _0343_ sky130_fd_sc_hd__nor2_1
X_0946_ _0338_ _0348_ _0396_ _0394_ net134 VGND VGND VPWR VPWR _0002_ sky130_fd_sc_hd__a32o_1
XFILLER_9_281 VGND VGND VPWR VPWR sky130_fd_sc_hd__decap_3
XFILLER_18_69 VPWR VGND VPWR VGND sky130_ef_sc_hd__decap_12
Xclkload1 clknet_3_2__leaf_clk VGND VGND VPWR VPWR clkload1/Y sky130_fd_sc_hd__clkinv_2
XFILLER_1_3 VPWR VGND VPWR VGND sky130_ef_sc_hd__decap_12
XPHY_EDGE_ROW_3_Left_53 VGND VGND VPWR VPWR sky130_fd_sc_hd__decap_3
X_0731_ _0245_ _0243_ _0237_ net121 VGND VGND VPWR VPWR net63 sky130_fd_sc_hd__o2bb2a_1
X_0800_ ten_mo\[3\] _0280_ _0288_ ten_mo\[2\] VGND VGND VPWR VPWR net44 sky130_fd_sc_hd__o31a_1
XFILLER_6_251 VGND VGND VPWR VPWR sky130_fd_sc_hd__fill_1
XFILLER_34_3 VGND VGND VPWR VPWR sky130_fd_sc_hd__decap_3
X_0662_ _0082_ _0194_ _0193_ VGND VGND VPWR VPWR net74 sky130_fd_sc_hd__mux2_1
X_0593_ _0100_ _0144_ _0145_ _0146_ VGND VGND VPWR VPWR _0147_ sky130_fd_sc_hd__or4_1
X_1145_ clknet_3_7__leaf_clk _0013_ net143 VGND VGND VPWR VPWR top_counter.leap_year_check.u\[1\]
+ sky130_fd_sc_hd__dfrtp_4
XFILLER_37_166 VGND VGND VPWR VPWR sky130_fd_sc_hd__fill_2
XFILLER_37_122 VPWR VGND VPWR VGND sky130_ef_sc_hd__decap_12
XFILLER_1_94 VGND VGND VPWR VPWR sky130_fd_sc_hd__fill_2
X_1076_ _0479_ hour_counter_alarm.ten_h_alarm\[0\] hour_counter_alarm.ten_h_alarm\[1\]
+ _0480_ VGND VGND VPWR VPWR _0481_ sky130_fd_sc_hd__and4bb_1
X_0929_ _0189_ _0373_ VGND VGND VPWR VPWR _0382_ sky130_fd_sc_hd__or2_1
XFILLER_20_15 VGND VGND VPWR VPWR sky130_fd_sc_hd__decap_4
XPHY_EDGE_ROW_45_Left_95 VGND VGND VPWR VPWR sky130_fd_sc_hd__decap_3
Xhold13 hour_counter_alarm.ten_h_alarm\[0\] VGND VGND VPWR VPWR net167 sky130_fd_sc_hd__dlygate4sd3_1
XFILLER_29_24 VGND VGND VPWR VPWR sky130_fd_sc_hd__fill_1
XFILLER_43_169 VPWR VGND VPWR VGND sky130_ef_sc_hd__decap_12
XFILLER_28_177 VPWR VGND VPWR VGND sky130_ef_sc_hd__decap_12
XFILLER_3_265 VPWR VGND VPWR VGND sky130_ef_sc_hd__decap_12
X_0645_ net126 _0090_ VGND VGND VPWR VPWR _0183_ sky130_fd_sc_hd__nand2_1
X_0714_ _0229_ _0231_ _0224_ VGND VGND VPWR VPWR net73 sky130_fd_sc_hd__o21bai_1
X_0576_ top_counter.hour_counter.unit_h\[3\] hour_counter_alarm.unit_h_alarm\[3\]
+ VGND VGND VPWR VPWR _0131_ sky130_fd_sc_hd__and2b_1
X_1059_ top_counter.second_counter.unit_s\[2\] _0469_ VGND VGND VPWR VPWR _0042_ sky130_fd_sc_hd__xor2_1
XFILLER_15_26 VPWR VGND VPWR VGND sky130_ef_sc_hd__decap_12
X_1128_ control_unit.current_state\[1\] _0512_ VGND VGND VPWR VPWR _0513_ sky130_fd_sc_hd__nor2_1
XFILLER_25_103 VGND VGND VPWR VPWR sky130_fd_sc_hd__fill_1
XFILLER_25_169 VGND VGND VPWR VPWR sky130_fd_sc_hd__decap_8
XFILLER_40_139 VGND VGND VPWR VPWR sky130_fd_sc_hd__fill_1
Xoutput58 net58 VGND VGND VPWR VPWR led_ten_y[5] sky130_fd_sc_hd__buf_2
Xoutput14 net14 VGND VGND VPWR VPWR led_hun_y[3] sky130_fd_sc_hd__buf_2
Xoutput47 net47 VGND VGND VPWR VPWR led_ten_s[1] sky130_fd_sc_hd__buf_2
Xoutput36 net36 VGND VGND VPWR VPWR led_ten_m[4] sky130_fd_sc_hd__buf_2
Xoutput25 net25 VGND VGND VPWR VPWR led_ten_h[0] sky130_fd_sc_hd__buf_2
Xoutput69 net69 VGND VGND VPWR VPWR led_unit_h[2] sky130_fd_sc_hd__buf_2
XFILLER_21_91 VGND VGND VPWR VPWR sky130_fd_sc_hd__decap_3
XFILLER_22_106 VPWR VGND VPWR VGND sky130_ef_sc_hd__decap_12
XFILLER_30_194 VGND VGND VPWR VPWR sky130_fd_sc_hd__fill_2
XFILLER_22_139 VGND VGND VPWR VPWR sky130_fd_sc_hd__fill_1
X_0628_ net128 top_counter.leap_year_check.u\[1\] VGND VGND VPWR VPWR _0173_ sky130_fd_sc_hd__nand2b_1
XFILLER_7_82 VPWR VGND VPWR VGND sky130_ef_sc_hd__decap_12
XFILLER_7_60 VGND VGND VPWR VPWR sky130_fd_sc_hd__fill_1
X_1222__154 VGND VGND VPWR VPWR net154 _1222__154/LO sky130_fd_sc_hd__conb_1
X_0559_ top_counter.min_counter.t2 min_counter_alarm.ten_m_alarm\[2\] VGND VGND VPWR
+ VPWR _0114_ sky130_fd_sc_hd__xor2_1
XFILLER_26_58 VGND VGND VPWR VPWR sky130_fd_sc_hd__decap_6
XFILLER_36_209 VPWR VGND VPWR VGND sky130_ef_sc_hd__decap_12
XFILLER_29_250 VPWR VGND VPWR VGND sky130_ef_sc_hd__decap_12
XFILLER_44_286 VGND VGND VPWR VPWR sky130_fd_sc_hd__decap_6
XPHY_EDGE_ROW_32_Left_82 VGND VGND VPWR VPWR sky130_fd_sc_hd__decap_3
XTAP_TAPCELL_ROW_14_178 VGND VPWR sky130_fd_sc_hd__tapvpwrvgnd_1
XFILLER_8_165 VGND VGND VPWR VPWR sky130_fd_sc_hd__decap_4
XFILLER_35_275 VGND VGND VPWR VPWR sky130_fd_sc_hd__decap_4
XFILLER_10_109 VGND VGND VPWR VPWR sky130_fd_sc_hd__decap_8
XFILLER_12_27 VGND VGND VPWR VPWR sky130_fd_sc_hd__fill_1
XFILLER_26_253 VGND VGND VPWR VPWR sky130_fd_sc_hd__decap_8
XTAP_TAPCELL_ROW_28_248 VGND VPWR sky130_fd_sc_hd__tapvpwrvgnd_1
XFILLER_41_201 VGND VGND VPWR VPWR sky130_fd_sc_hd__fill_2
XFILLER_5_113 VGND VGND VPWR VPWR sky130_fd_sc_hd__decap_6
XTAP_TAPCELL_ROW_19_204 VGND VPWR sky130_fd_sc_hd__tapvpwrvgnd_1
XFILLER_32_245 VGND VGND VPWR VPWR sky130_fd_sc_hd__decap_6
XFILLER_17_231 VPWR VGND VPWR VGND sky130_ef_sc_hd__decap_12
X_0962_ _0305_ _0402_ _0404_ _0407_ VGND VGND VPWR VPWR _0410_ sky130_fd_sc_hd__and4_1
XFILLER_32_289 VGND VGND VPWR VPWR sky130_fd_sc_hd__decap_3
X_0893_ net113 ten_s\[3\] net112 ten_s\[0\] VGND VGND VPWR VPWR _0353_ sky130_fd_sc_hd__or4bb_1
XFILLER_4_83 VGND VGND VPWR VPWR sky130_fd_sc_hd__fill_1
XTAP_TAPCELL_ROW_2_116 VGND VPWR sky130_fd_sc_hd__tapvpwrvgnd_1
XTAP_TAPCELL_ROW_33_273 VGND VPWR sky130_fd_sc_hd__tapvpwrvgnd_1
XFILLER_23_15 VPWR VGND VPWR VGND sky130_ef_sc_hd__decap_12
XFILLER_23_201 VPWR VGND VPWR VGND sky130_ef_sc_hd__decap_12
XFILLER_23_256 VPWR VGND VPWR VGND sky130_ef_sc_hd__decap_12
XFILLER_2_138 VGND VGND VPWR VPWR sky130_fd_sc_hd__fill_2
XFILLER_14_201 VGND VGND VPWR VPWR sky130_fd_sc_hd__fill_1
XFILLER_14_245 VGND VGND VPWR VPWR sky130_fd_sc_hd__decap_6
XFILLER_36_7 VGND VGND VPWR VPWR sky130_fd_sc_hd__fill_2
XFILLER_49_197 VGND VGND VPWR VPWR sky130_fd_sc_hd__fill_2
XFILLER_49_175 VGND VGND VPWR VPWR sky130_fd_sc_hd__decap_3
XTAP_TAPCELL_ROW_47_343 VGND VPWR sky130_fd_sc_hd__tapvpwrvgnd_1
X_1161_ clknet_3_2__leaf_clk _0029_ net139 VGND VGND VPWR VPWR min_counter_alarm.ten_m_alarm\[1\]
+ sky130_fd_sc_hd__dfrtp_2
X_1092_ min_counter_alarm.unit_m_alarm\[0\] min_counter_alarm.unit_m_alarm\[1\] VGND
+ VGND VPWR VPWR _0492_ sky130_fd_sc_hd__nand2_1
X_0876_ ten_d\[0\] _0341_ _0342_ net133 VGND VGND VPWR VPWR net20 sky130_fd_sc_hd__a22o_1
X_0945_ net135 _0394_ _0396_ _0344_ VGND VGND VPWR VPWR _0001_ sky130_fd_sc_hd__a22o_1
XFILLER_18_26 VGND VGND VPWR VPWR sky130_fd_sc_hd__fill_2
Xclkload2 clknet_3_3__leaf_clk VGND VGND VPWR VPWR clkload2/Y sky130_fd_sc_hd__clkinv_4
XTAP_TAPCELL_ROW_21_210 VGND VPWR sky130_fd_sc_hd__tapvpwrvgnd_1
X_0730_ _0245_ VGND VGND VPWR VPWR _0246_ sky130_fd_sc_hd__inv_2
X_0661_ _0079_ net116 top_counter.min_counter.u3 _0190_ VGND VGND VPWR VPWR _0194_
+ sky130_fd_sc_hd__o22a_1
X_0592_ _0102_ _0108_ _0119_ _0131_ VGND VGND VPWR VPWR _0146_ sky130_fd_sc_hd__or4_1
X_1144_ clknet_3_7__leaf_clk _0012_ net143 VGND VGND VPWR VPWR top_counter.leap_year_check.u\[0\]
+ sky130_fd_sc_hd__dfstp_2
XFILLER_37_189 VGND VGND VPWR VPWR sky130_fd_sc_hd__decap_3
XFILLER_37_134 VPWR VGND VPWR VGND sky130_ef_sc_hd__decap_12
X_1075_ hour_counter_alarm.unit_h_alarm\[0\] hour_counter_alarm.unit_h_alarm\[1\]
+ VGND VGND VPWR VPWR _0480_ sky130_fd_sc_hd__and2_1
X_0928_ net127 _0182_ _0290_ VGND VGND VPWR VPWR _0381_ sky130_fd_sc_hd__or3_1
X_0859_ _0322_ _0327_ VGND VGND VPWR VPWR _0332_ sky130_fd_sc_hd__nand2b_1
Xhold14 control_unit.select_time\[2\] VGND VGND VPWR VPWR net168 sky130_fd_sc_hd__dlygate4sd3_1
XFILLER_45_57 VPWR VGND VPWR VGND sky130_ef_sc_hd__decap_12
XFILLER_45_35 VGND VGND VPWR VPWR sky130_fd_sc_hd__fill_1
XFILLER_28_189 VGND VGND VPWR VPWR sky130_fd_sc_hd__decap_6
XFILLER_6_29 VGND VGND VPWR VPWR sky130_fd_sc_hd__decap_6
XFILLER_3_277 VGND VGND VPWR VPWR sky130_fd_sc_hd__decap_3
XFILLER_3_222 VGND VGND VPWR VPWR sky130_fd_sc_hd__fill_2
XFILLER_35_90 VGND VGND VPWR VPWR sky130_fd_sc_hd__fill_1
X_0713_ _0224_ _0230_ VGND VGND VPWR VPWR net72 sky130_fd_sc_hd__or2_1
X_0644_ _0181_ _0182_ net125 _0179_ VGND VGND VPWR VPWR net82 sky130_fd_sc_hd__a2bb2o_1
X_0575_ _0126_ _0127_ _0128_ _0129_ VGND VGND VPWR VPWR _0130_ sky130_fd_sc_hd__or4_1
XFILLER_33_181 VPWR VGND VPWR VGND sky130_ef_sc_hd__decap_12
XFILLER_15_38 VGND VGND VPWR VPWR sky130_fd_sc_hd__decap_3
X_1058_ _0467_ _0468_ _0469_ VGND VGND VPWR VPWR _0041_ sky130_fd_sc_hd__nor3_1
X_1127_ _0097_ _0507_ VGND VGND VPWR VPWR _0512_ sky130_fd_sc_hd__nand2_1
Xoutput59 net59 VGND VGND VPWR VPWR led_ten_y[6] sky130_fd_sc_hd__buf_2
Xoutput15 net15 VGND VGND VPWR VPWR led_hun_y[4] sky130_fd_sc_hd__buf_2
XPHY_EDGE_ROW_1_Right_1 VGND VGND VPWR VPWR sky130_fd_sc_hd__decap_3
XFILLER_0_225 VGND VGND VPWR VPWR sky130_fd_sc_hd__fill_2
XFILLER_0_203 VGND VGND VPWR VPWR sky130_fd_sc_hd__decap_3
Xoutput48 net48 VGND VGND VPWR VPWR led_ten_s[2] sky130_fd_sc_hd__buf_2
Xoutput37 net37 VGND VGND VPWR VPWR led_ten_m[5] sky130_fd_sc_hd__buf_2
Xoutput26 net26 VGND VGND VPWR VPWR led_ten_h[1] sky130_fd_sc_hd__buf_2
XFILLER_48_229 VPWR VGND VPWR VGND sky130_ef_sc_hd__decap_12
XFILLER_48_218 VGND VGND VPWR VPWR sky130_fd_sc_hd__decap_4
XFILLER_16_137 VGND VGND VPWR VPWR sky130_fd_sc_hd__decap_3
XFILLER_21_81 VGND VGND VPWR VPWR sky130_fd_sc_hd__decap_4
XFILLER_22_118 VGND VGND VPWR VPWR sky130_fd_sc_hd__decap_6
XFILLER_22_129 VGND VGND VPWR VPWR sky130_fd_sc_hd__fill_2
X_0627_ top_counter.leap_year_check.u\[1\] top_counter.leap_year_check.u\[3\] VGND
+ VGND VPWR VPWR _0172_ sky130_fd_sc_hd__nand2_1
XFILLER_7_94 VGND VGND VPWR VPWR sky130_fd_sc_hd__decap_4
X_0558_ top_counter.min_counter.t1 min_counter_alarm.ten_m_alarm\[1\] VGND VGND VPWR
+ VPWR _0113_ sky130_fd_sc_hd__or2_1
XFILLER_44_221 VPWR VGND VPWR VGND sky130_ef_sc_hd__decap_12
XFILLER_29_262 VGND VGND VPWR VPWR sky130_fd_sc_hd__decap_6
XTAP_TAPCELL_ROW_14_179 VGND VPWR sky130_fd_sc_hd__tapvpwrvgnd_1
XTAP_TAPCELL_ROW_28_249 VGND VPWR sky130_fd_sc_hd__tapvpwrvgnd_1
XFILLER_5_169 VPWR VGND VPWR VGND sky130_ef_sc_hd__decap_12
X_0961_ net162 _0409_ VGND VGND VPWR VPWR _0004_ sky130_fd_sc_hd__xnor2_1
XFILLER_17_243 VPWR VGND VPWR VGND sky130_ef_sc_hd__decap_12
X_0892_ _0086_ ten_s\[2\] VGND VGND VPWR VPWR _0352_ sky130_fd_sc_hd__nand2_1
XTAP_TAPCELL_ROW_2_117 VGND VPWR sky130_fd_sc_hd__tapvpwrvgnd_1
XFILLER_23_213 VGND VGND VPWR VPWR sky130_fd_sc_hd__decap_8
XTAP_TAPCELL_ROW_33_274 VGND VPWR sky130_fd_sc_hd__tapvpwrvgnd_1
XFILLER_23_27 VPWR VGND VPWR VGND sky130_ef_sc_hd__decap_12
XFILLER_23_268 VPWR VGND VPWR VGND sky130_ef_sc_hd__decap_12
XFILLER_2_128 VGND VGND VPWR VPWR sky130_fd_sc_hd__fill_1
XFILLER_1_172 VGND VGND VPWR VPWR sky130_fd_sc_hd__decap_8
XFILLER_49_154 VGND VGND VPWR VPWR sky130_fd_sc_hd__decap_3
XTAP_TAPCELL_ROW_47_344 VGND VPWR sky130_fd_sc_hd__tapvpwrvgnd_1
Xclkbuf_3_7__f_clk clknet_0_clk VGND VGND VPWR VPWR clknet_3_7__leaf_clk sky130_fd_sc_hd__clkbuf_16
X_1160_ clknet_3_2__leaf_clk _0028_ net139 VGND VGND VPWR VPWR min_counter_alarm.ten_m_alarm\[0\]
+ sky130_fd_sc_hd__dfrtp_1
X_1091_ _0441_ _0491_ min_counter_alarm.unit_m_alarm\[0\] VGND VGND VPWR VPWR _0052_
+ sky130_fd_sc_hd__mux2_1
X_0944_ _0394_ _0396_ _0094_ VGND VGND VPWR VPWR _0000_ sky130_fd_sc_hd__mux2_1
X_0875_ net132 net135 VGND VGND VPWR VPWR _0342_ sky130_fd_sc_hd__nand2b_1
XTAP_TAPCELL_ROW_30_255 VGND VPWR sky130_fd_sc_hd__tapvpwrvgnd_1
Xclkload3 clknet_3_4__leaf_clk VGND VGND VPWR VPWR clkload3/Y sky130_fd_sc_hd__clkinvlp_4
XTAP_TAPCELL_ROW_21_211 VGND VPWR sky130_fd_sc_hd__tapvpwrvgnd_1
XFILLER_46_135 VGND VGND VPWR VPWR sky130_fd_sc_hd__decap_4
XTAP_TAPCELL_ROW_44_325 VGND VPWR sky130_fd_sc_hd__tapvpwrvgnd_1
X_0660_ _0192_ VGND VGND VPWR VPWR _0193_ sky130_fd_sc_hd__inv_2
X_0591_ _0099_ _0101_ _0104_ _0117_ VGND VGND VPWR VPWR _0145_ sky130_fd_sc_hd__or4_1
X_1143_ clknet_3_7__leaf_clk _0011_ net144 VGND VGND VPWR VPWR ten_y\[3\] sky130_fd_sc_hd__dfrtp_1
XFILLER_37_146 VPWR VGND VPWR VGND sky130_ef_sc_hd__decap_12
X_1074_ hour_counter_alarm.ten_h_alarm\[2\] hour_counter_alarm.ten_h_alarm\[3\] hour_counter_alarm.unit_h_alarm\[2\]
+ hour_counter_alarm.unit_h_alarm\[3\] VGND VGND VPWR VPWR _0479_ sky130_fd_sc_hd__or4_1
X_0927_ _0178_ _0182_ _0290_ VGND VGND VPWR VPWR _0380_ sky130_fd_sc_hd__or3_1
X_0789_ ten_mo\[2\] _0282_ _0284_ _0285_ VGND VGND VPWR VPWR net40 sky130_fd_sc_hd__o2bb2a_1
X_0858_ net112 _0327_ VGND VGND VPWR VPWR _0331_ sky130_fd_sc_hd__nand2_1
Xhold15 control_unit.select_time\[4\] VGND VGND VPWR VPWR net169 sky130_fd_sc_hd__dlygate4sd3_1
XFILLER_45_69 VGND VGND VPWR VPWR sky130_fd_sc_hd__decap_4
XFILLER_10_83 VGND VGND VPWR VPWR sky130_fd_sc_hd__fill_1
X_0574_ top_counter.hour_counter.unit_h\[0\] hour_counter_alarm.unit_h_alarm\[0\]
+ VGND VGND VPWR VPWR _0129_ sky130_fd_sc_hd__and2b_1
X_0712_ _0218_ _0232_ _0233_ VGND VGND VPWR VPWR net71 sky130_fd_sc_hd__mux2_1
X_0643_ net125 net124 VGND VGND VPWR VPWR _0182_ sky130_fd_sc_hd__or2_1
X_1126_ control_unit.current_state\[1\] _0511_ VGND VGND VPWR VPWR _0067_ sky130_fd_sc_hd__and2_1
XFILLER_33_193 VPWR VGND VPWR VGND sky130_ef_sc_hd__decap_12
X_1057_ _0137_ _0466_ VGND VGND VPWR VPWR _0469_ sky130_fd_sc_hd__nor2_1
Xoutput16 net16 VGND VGND VPWR VPWR led_hun_y[5] sky130_fd_sc_hd__buf_2
Xoutput49 net49 VGND VGND VPWR VPWR led_ten_s[3] sky130_fd_sc_hd__buf_2
Xoutput38 net38 VGND VGND VPWR VPWR led_ten_m[6] sky130_fd_sc_hd__buf_2
Xoutput27 net27 VGND VGND VPWR VPWR led_ten_h[2] sky130_fd_sc_hd__buf_2
XFILLER_24_182 VGND VGND VPWR VPWR sky130_fd_sc_hd__fill_2
Xclkbuf_0_clk clk VGND VGND VPWR VPWR clknet_0_clk sky130_fd_sc_hd__clkbuf_16
XFILLER_30_185 VGND VGND VPWR VPWR sky130_fd_sc_hd__decap_3
XFILLER_30_141 VPWR VGND VPWR VGND sky130_ef_sc_hd__decap_12
X_0626_ _0171_ net129 net128 VGND VGND VPWR VPWR net96 sky130_fd_sc_hd__mux2_1
X_0557_ top_counter.min_counter.t1 min_counter_alarm.ten_m_alarm\[1\] VGND VGND VPWR
+ VPWR _0112_ sky130_fd_sc_hd__nand2_1
XPHY_EDGE_ROW_15_Right_15 VGND VGND VPWR VPWR sky130_fd_sc_hd__decap_3
X_1109_ net106 _0476_ VGND VGND VPWR VPWR _0500_ sky130_fd_sc_hd__and2b_1
XPHY_EDGE_ROW_24_Right_24 VGND VGND VPWR VPWR sky130_fd_sc_hd__decap_3
XFILLER_42_15 VPWR VGND VPWR VGND sky130_ef_sc_hd__decap_12
XFILLER_21_185 VGND VGND VPWR VPWR sky130_fd_sc_hd__fill_1
XPHY_EDGE_ROW_33_Right_33 VGND VGND VPWR VPWR sky130_fd_sc_hd__decap_3
XTAP_TAPCELL_ROW_8_145 VGND VPWR sky130_fd_sc_hd__tapvpwrvgnd_1
XFILLER_44_233 VPWR VGND VPWR VGND sky130_ef_sc_hd__decap_12
XPHY_EDGE_ROW_42_Right_42 VGND VGND VPWR VPWR sky130_fd_sc_hd__decap_3
XFILLER_16_93 VGND VGND VPWR VPWR sky130_fd_sc_hd__fill_2
XFILLER_32_81 VGND VGND VPWR VPWR sky130_fd_sc_hd__decap_3
XFILLER_8_178 VPWR VGND VPWR VGND sky130_ef_sc_hd__decap_12
XFILLER_12_141 VGND VGND VPWR VPWR sky130_fd_sc_hd__fill_2
XFILLER_12_152 VGND VGND VPWR VPWR sky130_fd_sc_hd__fill_1
XPHY_EDGE_ROW_19_Left_69 VGND VGND VPWR VPWR sky130_fd_sc_hd__decap_3
X_0609_ top_counter.second_counter.unit_s\[0\] _0154_ _0160_ _0159_ _0084_ VGND VGND
+ VPWR VPWR net90 sky130_fd_sc_hd__o32a_1
XFILLER_26_222 VGND VGND VPWR VPWR sky130_fd_sc_hd__decap_8
XFILLER_41_258 VGND VGND VPWR VPWR sky130_fd_sc_hd__decap_3
XFILLER_17_222 VGND VGND VPWR VPWR sky130_fd_sc_hd__fill_2
XFILLER_17_255 VGND VGND VPWR VPWR sky130_fd_sc_hd__decap_4
XFILLER_27_81 VPWR VGND VPWR VGND sky130_ef_sc_hd__decap_12
X_0960_ _0402_ _0408_ VGND VGND VPWR VPWR _0409_ sky130_fd_sc_hd__nand2_1
X_0891_ _0350_ _0351_ VGND VGND VPWR VPWR control_unit.next_state\[1\] sky130_fd_sc_hd__nor2_1
XFILLER_4_63 VPWR VGND VPWR VGND sky130_ef_sc_hd__decap_12
XFILLER_4_41 VGND VGND VPWR VPWR sky130_fd_sc_hd__decap_8
XTAP_TAPCELL_ROW_2_118 VGND VPWR sky130_fd_sc_hd__tapvpwrvgnd_1
XFILLER_23_225 VPWR VGND VPWR VGND sky130_ef_sc_hd__decap_12
XFILLER_23_39 VPWR VGND VPWR VGND sky130_ef_sc_hd__decap_12
XFILLER_14_214 VPWR VGND VPWR VGND sky130_ef_sc_hd__decap_12
XFILLER_14_258 VGND VGND VPWR VPWR sky130_fd_sc_hd__fill_1
XFILLER_49_133 VGND VGND VPWR VPWR sky130_fd_sc_hd__decap_3
XFILLER_1_151 VGND VGND VPWR VPWR sky130_fd_sc_hd__decap_4
X_1090_ net107 _0438_ VGND VGND VPWR VPWR _0491_ sky130_fd_sc_hd__and2b_1
X_0874_ net135 net132 VGND VGND VPWR VPWR _0341_ sky130_fd_sc_hd__nand2_1
X_0943_ _0372_ _0395_ VGND VGND VPWR VPWR _0396_ sky130_fd_sc_hd__nor2_1
XTAP_TAPCELL_ROW_30_256 VGND VPWR sky130_fd_sc_hd__tapvpwrvgnd_1
XFILLER_20_217 VGND VGND VPWR VPWR sky130_fd_sc_hd__fill_2
XFILLER_20_239 VPWR VGND VPWR VGND sky130_ef_sc_hd__decap_12
Xclkload4 clknet_3_5__leaf_clk VGND VGND VPWR VPWR clkload4/Y sky130_fd_sc_hd__clkinv_2
XTAP_TAPCELL_ROW_21_212 VGND VPWR sky130_fd_sc_hd__tapvpwrvgnd_1
XTAP_TAPCELL_ROW_44_326 VGND VPWR sky130_fd_sc_hd__tapvpwrvgnd_1
XFILLER_40_92 VPWR VGND VPWR VGND sky130_ef_sc_hd__decap_12
X_0590_ net115 _0078_ _0134_ VGND VGND VPWR VPWR _0144_ sky130_fd_sc_hd__a21o_1
X_1142_ clknet_3_7__leaf_clk _0010_ net143 VGND VGND VPWR VPWR ten_y\[2\] sky130_fd_sc_hd__dfrtp_1
XFILLER_37_169 VPWR VGND VPWR VGND sky130_ef_sc_hd__decap_12
XFILLER_37_158 VGND VGND VPWR VPWR sky130_fd_sc_hd__decap_8
X_1073_ _0477_ VGND VGND VPWR VPWR _0478_ sky130_fd_sc_hd__inv_2
X_0926_ _0377_ _0378_ _0373_ VGND VGND VPWR VPWR _0379_ sky130_fd_sc_hd__a21o_1
X_0857_ net114 _0325_ _0330_ _0329_ _0086_ VGND VGND VPWR VPWR net48 sky130_fd_sc_hd__o32a_1
X_0788_ net123 ten_mo\[0\] _0092_ VGND VGND VPWR VPWR _0285_ sky130_fd_sc_hd__o21a_1
Xhold16 top_counter.second_counter.unit_s\[0\] VGND VGND VPWR VPWR net170 sky130_fd_sc_hd__dlygate4sd3_1
XFILLER_45_15 VPWR VGND VPWR VGND sky130_ef_sc_hd__decap_12
XFILLER_43_117 VPWR VGND VPWR VGND sky130_ef_sc_hd__decap_12
XFILLER_43_106 VGND VGND VPWR VPWR sky130_fd_sc_hd__decap_6
XPHY_EDGE_ROW_7_Left_57 VGND VGND VPWR VPWR sky130_fd_sc_hd__decap_3
XFILLER_3_213 VGND VGND VPWR VPWR sky130_fd_sc_hd__fill_1
XFILLER_34_139 VGND VGND VPWR VPWR sky130_fd_sc_hd__fill_1
X_0711_ _0210_ _0214_ _0222_ VGND VGND VPWR VPWR _0233_ sky130_fd_sc_hd__or3_1
X_0573_ top_counter.min_counter.u3 min_counter_alarm.unit_m_alarm\[3\] VGND VGND VPWR
+ VPWR _0128_ sky130_fd_sc_hd__and2b_1
X_0642_ net127 net126 VGND VGND VPWR VPWR _0181_ sky130_fd_sc_hd__nor2_1
X_1125_ control_unit.mode_alarm\[1\] _0508_ _0510_ VGND VGND VPWR VPWR _0511_ sky130_fd_sc_hd__a21bo_1
XPHY_EDGE_ROW_49_Left_99 VGND VGND VPWR VPWR sky130_fd_sc_hd__decap_3
XFILLER_33_161 VGND VGND VPWR VPWR sky130_fd_sc_hd__decap_6
X_1056_ _0355_ _0466_ VGND VGND VPWR VPWR _0468_ sky130_fd_sc_hd__nor2_2
XFILLER_15_18 VGND VGND VPWR VPWR sky130_fd_sc_hd__decap_4
Xoutput39 net39 VGND VGND VPWR VPWR led_ten_mo[0] sky130_fd_sc_hd__buf_2
Xoutput17 net17 VGND VGND VPWR VPWR led_hun_y[6] sky130_fd_sc_hd__buf_2
X_0909_ _0363_ _0364_ VGND VGND VPWR VPWR top_counter.min_counter.d_t0 sky130_fd_sc_hd__nor2_1
Xoutput28 net28 VGND VGND VPWR VPWR led_ten_h[3] sky130_fd_sc_hd__buf_2
XFILLER_48_209 VGND VGND VPWR VPWR sky130_fd_sc_hd__fill_2
XFILLER_0_216 VGND VGND VPWR VPWR sky130_fd_sc_hd__decap_4
XFILLER_31_109 VGND VGND VPWR VPWR sky130_fd_sc_hd__decap_3
XFILLER_16_128 VGND VGND VPWR VPWR sky130_fd_sc_hd__fill_2
XFILLER_47_242 VPWR VGND VPWR VGND sky130_ef_sc_hd__decap_12
XFILLER_30_153 VPWR VGND VPWR VGND sky130_ef_sc_hd__decap_12
XFILLER_15_183 VGND VGND VPWR VPWR sky130_fd_sc_hd__decap_8
X_0625_ top_counter.leap_year_check.u\[2\] _0167_ _0169_ VGND VGND VPWR VPWR _0171_
+ sky130_fd_sc_hd__a21oi_1
XFILLER_30_197 VPWR VGND VPWR VGND sky130_ef_sc_hd__decap_12
X_0556_ min_counter_alarm.ten_m_alarm\[3\] _0108_ _0109_ _0110_ VGND VGND VPWR VPWR
+ _0111_ sky130_fd_sc_hd__or4_1
X_1108_ net171 _0498_ _0499_ net161 VGND VGND VPWR VPWR _0061_ sky130_fd_sc_hd__a22o_1
X_1039_ _0368_ _0451_ VGND VGND VPWR VPWR _0458_ sky130_fd_sc_hd__and2_1
XFILLER_26_39 VPWR VGND VPWR VGND sky130_ef_sc_hd__decap_12
XFILLER_42_27 VGND VGND VPWR VPWR sky130_fd_sc_hd__fill_1
XTAP_TAPCELL_ROW_8_146 VGND VPWR sky130_fd_sc_hd__tapvpwrvgnd_1
XFILLER_44_245 VGND VGND VPWR VPWR sky130_fd_sc_hd__decap_6
XFILLER_16_83 VGND VGND VPWR VPWR sky130_fd_sc_hd__fill_1
XFILLER_12_197 VGND VGND VPWR VPWR sky130_fd_sc_hd__fill_1
XFILLER_35_289 VGND VGND VPWR VPWR sky130_fd_sc_hd__decap_3
XFILLER_35_223 VGND VGND VPWR VPWR sky130_fd_sc_hd__fill_1
XTAP_TAPCELL_ROW_13_170 VGND VPWR sky130_fd_sc_hd__tapvpwrvgnd_1
XFILLER_7_190 VPWR VGND VPWR VGND sky130_ef_sc_hd__decap_12
X_0608_ top_counter.second_counter.unit_s\[1\] top_counter.second_counter.unit_s\[2\]
+ VGND VGND VPWR VPWR _0160_ sky130_fd_sc_hd__and2b_1
X_0539_ ten_d\[0\] VGND VGND VPWR VPWR _0094_ sky130_fd_sc_hd__inv_2
XFILLER_26_289 VGND VGND VPWR VPWR sky130_fd_sc_hd__decap_3
XPHY_EDGE_ROW_36_Left_86 VGND VGND VPWR VPWR sky130_fd_sc_hd__decap_3
XTAP_TAPCELL_ROW_27_240 VGND VPWR sky130_fd_sc_hd__tapvpwrvgnd_1
XFILLER_27_93 VPWR VGND VPWR VGND sky130_ef_sc_hd__decap_12
XFILLER_40_270 VGND VGND VPWR VPWR sky130_fd_sc_hd__decap_3
X_0890_ control_unit.current_state\[0\] net2 control_unit.current_state\[1\] VGND
+ VGND VPWR VPWR _0351_ sky130_fd_sc_hd__o21a_1
XFILLER_4_160 VPWR VGND VPWR VGND sky130_ef_sc_hd__decap_12
XFILLER_4_75 VGND VGND VPWR VPWR sky130_fd_sc_hd__decap_8
XTAP_TAPCELL_ROW_2_119 VGND VPWR sky130_fd_sc_hd__tapvpwrvgnd_1
XFILLER_23_237 VGND VGND VPWR VPWR sky130_fd_sc_hd__decap_4
XFILLER_31_281 VGND VGND VPWR VPWR sky130_fd_sc_hd__fill_2
XFILLER_48_15 VPWR VGND VPWR VGND sky130_ef_sc_hd__decap_12
XFILLER_14_226 VPWR VGND VPWR VGND sky130_ef_sc_hd__decap_12
XFILLER_49_189 VGND VGND VPWR VPWR sky130_fd_sc_hd__decap_3
XFILLER_38_81 VGND VGND VPWR VPWR sky130_fd_sc_hd__decap_3
XFILLER_1_130 VGND VGND VPWR VPWR sky130_fd_sc_hd__fill_2
X_0873_ net133 _0335_ _0339_ _0340_ VGND VGND VPWR VPWR net19 sky130_fd_sc_hd__a22o_1
X_0942_ _0370_ _0393_ VGND VGND VPWR VPWR _0395_ sky130_fd_sc_hd__nand2_1
XTAP_TAPCELL_ROW_30_257 VGND VPWR sky130_fd_sc_hd__tapvpwrvgnd_1
XFILLER_13_281 VPWR VGND VPWR VGND sky130_ef_sc_hd__decap_12
XFILLER_18_18 VGND VGND VPWR VPWR sky130_fd_sc_hd__fill_1
Xclkload5 clknet_3_6__leaf_clk VGND VGND VPWR VPWR clkload5/Y sky130_fd_sc_hd__clkinvlp_4
XTAP_TAPCELL_ROW_21_213 VGND VPWR sky130_fd_sc_hd__tapvpwrvgnd_1
XTAP_TAPCELL_ROW_44_327 VGND VPWR sky130_fd_sc_hd__tapvpwrvgnd_1
XFILLER_6_211 VPWR VGND VPWR VGND sky130_ef_sc_hd__decap_12
XFILLER_10_251 VGND VGND VPWR VPWR sky130_fd_sc_hd__fill_1
XFILLER_10_295 VGND VGND VPWR VPWR sky130_fd_sc_hd__fill_1
XFILLER_6_277 VPWR VGND VPWR VGND sky130_ef_sc_hd__decap_12
XFILLER_49_91 VGND VGND VPWR VPWR sky130_fd_sc_hd__decap_3
X_1141_ clknet_3_7__leaf_clk _0009_ net143 VGND VGND VPWR VPWR ten_y\[1\] sky130_fd_sc_hd__dfstp_1
X_1210_ clknet_3_1__leaf_clk control_unit.next_state\[1\] net138 VGND VGND VPWR VPWR
+ control_unit.current_state\[1\] sky130_fd_sc_hd__dfrtp_2
X_1072_ net106 _0476_ VGND VGND VPWR VPWR _0477_ sky130_fd_sc_hd__or2_2
XPHY_EDGE_ROW_23_Left_73 VGND VGND VPWR VPWR sky130_fd_sc_hd__decap_3
X_0787_ _0092_ _0093_ VGND VGND VPWR VPWR _0284_ sky130_fd_sc_hd__nor2_1
X_0925_ net127 top_counter.day_in_month_decode.unit_mo\[3\] top_counter.day_in_month_decode.unit_mo\[2\]
+ VGND VGND VPWR VPWR _0378_ sky130_fd_sc_hd__or3b_1
X_0856_ net113 net112 VGND VGND VPWR VPWR _0330_ sky130_fd_sc_hd__and2b_1
Xhold17 control_unit.select_time\[4\] VGND VGND VPWR VPWR net171 sky130_fd_sc_hd__dlygate4sd3_1
XFILLER_45_27 VGND VGND VPWR VPWR sky130_fd_sc_hd__decap_8
XFILLER_43_129 VPWR VGND VPWR VGND sky130_ef_sc_hd__decap_12
XFILLER_28_137 VGND VGND VPWR VPWR sky130_fd_sc_hd__decap_3
XFILLER_3_225 VGND VGND VPWR VPWR sky130_fd_sc_hd__fill_2
XFILLER_10_41 VGND VGND VPWR VPWR sky130_fd_sc_hd__decap_6
XFILLER_10_52 VGND VGND VPWR VPWR sky130_fd_sc_hd__decap_8
XFILLER_10_85 VPWR VGND VPWR VGND sky130_ef_sc_hd__decap_12
XFILLER_19_94 VGND VGND VPWR VPWR sky130_fd_sc_hd__decap_4
XFILLER_42_195 VGND VGND VPWR VPWR sky130_fd_sc_hd__fill_1
XFILLER_42_173 VGND VGND VPWR VPWR sky130_fd_sc_hd__fill_1
XFILLER_27_181 VPWR VGND VPWR VGND sky130_ef_sc_hd__decap_12
X_0710_ _0230_ _0231_ _0232_ VGND VGND VPWR VPWR net70 sky130_fd_sc_hd__o21bai_1
X_0641_ _0179_ _0180_ VGND VGND VPWR VPWR net81 sky130_fd_sc_hd__xnor2_1
X_0572_ min_counter_alarm.unit_m_alarm\[3\] top_counter.min_counter.u3 VGND VGND VPWR
+ VPWR _0127_ sky130_fd_sc_hd__and2b_1
X_1055_ _0083_ _0466_ top_counter.second_counter.unit_s\[1\] VGND VGND VPWR VPWR _0467_
+ sky130_fd_sc_hd__o21ba_1
X_1124_ control_unit.current_state\[1\] _0509_ _0510_ VGND VGND VPWR VPWR _0066_ sky130_fd_sc_hd__and3_1
Xoutput18 net18 VGND VGND VPWR VPWR led_ten_d[0] sky130_fd_sc_hd__buf_2
X_0839_ net59 _0317_ _0313_ VGND VGND VPWR VPWR net56 sky130_fd_sc_hd__or3b_1
X_0908_ net117 _0357_ _0358_ VGND VGND VPWR VPWR _0364_ sky130_fd_sc_hd__and3_1
Xoutput29 net29 VGND VGND VPWR VPWR led_ten_h[4] sky130_fd_sc_hd__buf_2
XFILLER_24_162 VPWR VGND VPWR VGND sky130_ef_sc_hd__decap_12
XFILLER_24_195 VGND VGND VPWR VPWR sky130_fd_sc_hd__fill_1
XFILLER_47_254 VPWR VGND VPWR VGND sky130_ef_sc_hd__decap_12
XFILLER_30_165 VPWR VGND VPWR VGND sky130_ef_sc_hd__decap_12
X_0624_ top_counter.leap_year_check.u\[3\] _0169_ VGND VGND VPWR VPWR _0170_ sky130_fd_sc_hd__or2_1
X_0555_ hour_counter_alarm.unit_h_alarm\[0\] top_counter.hour_counter.unit_h\[0\]
+ VGND VGND VPWR VPWR _0110_ sky130_fd_sc_hd__and2b_1
XPHY_EDGE_ROW_5_Right_5 VGND VGND VPWR VPWR sky130_fd_sc_hd__decap_3
X_1107_ net164 _0498_ _0499_ net169 VGND VGND VPWR VPWR _0060_ sky130_fd_sc_hd__a22o_1
X_1038_ _0455_ _0456_ _0457_ VGND VGND VPWR VPWR _0033_ sky130_fd_sc_hd__and3b_1
XTAP_TAPCELL_ROW_8_147 VGND VPWR sky130_fd_sc_hd__tapvpwrvgnd_1
XPHY_EDGE_ROW_10_Left_60 VGND VGND VPWR VPWR sky130_fd_sc_hd__decap_3
XFILLER_35_279 VGND VGND VPWR VPWR sky130_fd_sc_hd__fill_1
XTAP_TAPCELL_ROW_13_171 VGND VPWR sky130_fd_sc_hd__tapvpwrvgnd_1
X_0538_ ten_mo\[2\] VGND VGND VPWR VPWR _0093_ sky130_fd_sc_hd__inv_2
X_0607_ _0083_ top_counter.second_counter.unit_s\[1\] _0155_ VGND VGND VPWR VPWR _0159_
+ sky130_fd_sc_hd__o21bai_1
XTAP_TAPCELL_ROW_36_285 VGND VPWR sky130_fd_sc_hd__tapvpwrvgnd_1
XFILLER_5_139 VGND VGND VPWR VPWR sky130_fd_sc_hd__decap_8
XFILLER_17_279 VGND VGND VPWR VPWR sky130_fd_sc_hd__fill_1
XTAP_TAPCELL_ROW_27_241 VGND VPWR sky130_fd_sc_hd__tapvpwrvgnd_1
XFILLER_4_172 VPWR VGND VPWR VGND sky130_ef_sc_hd__decap_12
XFILLER_48_27 VGND VGND VPWR VPWR sky130_fd_sc_hd__fill_1
Xtop_century_clock_150 VGND VGND VPWR VPWR top_century_clock_150/HI led_thou_y[6]
+ sky130_fd_sc_hd__conb_1
XFILLER_14_238 VGND VGND VPWR VPWR sky130_fd_sc_hd__decap_4
XFILLER_1_142 VGND VGND VPWR VPWR sky130_fd_sc_hd__fill_2
XFILLER_49_113 VGND VGND VPWR VPWR sky130_fd_sc_hd__fill_2
X_0941_ _0372_ _0393_ _0370_ VGND VGND VPWR VPWR _0394_ sky130_fd_sc_hd__a21bo_1
X_0872_ ten_d\[3\] net133 VGND VGND VPWR VPWR _0340_ sky130_fd_sc_hd__nor2_1
XTAP_TAPCELL_ROW_30_258 VGND VPWR sky130_fd_sc_hd__tapvpwrvgnd_1
XFILLER_9_264 VPWR VGND VPWR VGND sky130_ef_sc_hd__decap_12
XFILLER_13_293 VGND VGND VPWR VPWR sky130_fd_sc_hd__decap_3
Xclkload6 clknet_3_7__leaf_clk VGND VGND VPWR VPWR clkload6/X sky130_fd_sc_hd__clkbuf_4
XFILLER_34_29 VGND VGND VPWR VPWR sky130_fd_sc_hd__decap_4
XFILLER_11_219 VGND VGND VPWR VPWR sky130_fd_sc_hd__decap_4
XTAP_TAPCELL_ROW_21_214 VGND VPWR sky130_fd_sc_hd__tapvpwrvgnd_1
XTAP_TAPCELL_ROW_44_328 VGND VPWR sky130_fd_sc_hd__tapvpwrvgnd_1
XFILLER_6_223 VPWR VGND VPWR VGND sky130_ef_sc_hd__decap_12
XFILLER_49_70 VGND VGND VPWR VPWR sky130_fd_sc_hd__decap_3
XFILLER_6_289 VGND VGND VPWR VPWR sky130_fd_sc_hd__decap_4
XFILLER_27_7 VGND VGND VPWR VPWR sky130_fd_sc_hd__decap_4
X_1140_ clknet_3_6__leaf_clk _0008_ net143 VGND VGND VPWR VPWR ten_y\[0\] sky130_fd_sc_hd__dfrtp_2
XFILLER_37_105 VGND VGND VPWR VPWR sky130_fd_sc_hd__decap_3
X_1071_ control_unit.mode_alarm\[1\] control_unit.mode_alarm\[0\] net1 VGND VGND VPWR
+ VPWR _0476_ sky130_fd_sc_hd__and3b_1
X_0924_ top_counter.day_in_month_decode.unit_mo\[1\] top_counter.day_in_month_decode.unit_mo\[2\]
+ top_counter.day_in_month_decode.unit_mo\[3\] net127 VGND VGND VPWR VPWR _0377_ sky130_fd_sc_hd__or4bb_1
X_0786_ _0091_ _0092_ _0093_ _0283_ VGND VGND VPWR VPWR net39 sky130_fd_sc_hd__a31o_1
X_0855_ net112 net104 _0328_ VGND VGND VPWR VPWR _0329_ sky130_fd_sc_hd__or3_1
XFILLER_28_105 VPWR VGND VPWR VGND sky130_ef_sc_hd__decap_12
XFILLER_10_97 VPWR VGND VPWR VGND sky130_ef_sc_hd__decap_12
XPHY_EDGE_ROW_40_Left_90 VGND VGND VPWR VPWR sky130_fd_sc_hd__decap_3
XFILLER_19_51 VGND VGND VPWR VPWR sky130_fd_sc_hd__decap_4
XFILLER_19_73 VGND VGND VPWR VPWR sky130_fd_sc_hd__fill_1
XFILLER_42_141 VPWR VGND VPWR VGND sky130_ef_sc_hd__decap_12
XFILLER_35_61 VPWR VGND VPWR VGND sky130_ef_sc_hd__decap_12
XFILLER_27_193 VGND VGND VPWR VPWR sky130_fd_sc_hd__decap_6
X_0571_ min_counter_alarm.ten_m_alarm\[0\] net117 VGND VGND VPWR VPWR _0126_ sky130_fd_sc_hd__and2b_1
X_0640_ _0089_ net126 net125 VGND VGND VPWR VPWR _0180_ sky130_fd_sc_hd__a21o_1
XFILLER_18_3 VGND VGND VPWR VPWR sky130_fd_sc_hd__fill_2
X_1054_ net170 _0466_ VGND VGND VPWR VPWR _0040_ sky130_fd_sc_hd__xnor2_1
X_1123_ control_unit.mode_alarm\[0\] _0507_ VGND VGND VPWR VPWR _0510_ sky130_fd_sc_hd__nand2_1
XFILLER_31_19 VPWR VGND VPWR VGND sky130_ef_sc_hd__decap_12
X_0907_ _0357_ _0358_ net117 VGND VGND VPWR VPWR _0363_ sky130_fd_sc_hd__a21oi_1
Xoutput19 net19 VGND VGND VPWR VPWR led_ten_d[1] sky130_fd_sc_hd__buf_2
X_0838_ ten_y\[0\] ten_y\[1\] net131 VGND VGND VPWR VPWR _0317_ sky130_fd_sc_hd__and3_1
X_0769_ net117 net115 top_counter.min_counter.t2 VGND VGND VPWR VPWR _0274_ sky130_fd_sc_hd__and3_1
XFILLER_24_141 VGND VGND VPWR VPWR sky130_fd_sc_hd__fill_1
XFILLER_24_174 VGND VGND VPWR VPWR sky130_fd_sc_hd__decap_8
XFILLER_21_85 VGND VGND VPWR VPWR sky130_fd_sc_hd__fill_1
XFILLER_47_266 VPWR VGND VPWR VGND sky130_ef_sc_hd__decap_12
XFILLER_30_177 VGND VGND VPWR VPWR sky130_fd_sc_hd__decap_8
XFILLER_7_54 VGND VGND VPWR VPWR sky130_fd_sc_hd__fill_2
X_0623_ top_counter.leap_year_check.u\[0\] top_counter.leap_year_check.u\[1\] VGND
+ VGND VPWR VPWR _0169_ sky130_fd_sc_hd__nor2_1
XFILLER_7_98 VGND VGND VPWR VPWR sky130_fd_sc_hd__fill_1
X_0554_ min_counter_alarm.unit_m_alarm\[2\] top_counter.min_counter.u2 VGND VGND VPWR
+ VPWR _0109_ sky130_fd_sc_hd__and2b_1
XFILLER_38_288 VGND VGND VPWR VPWR sky130_fd_sc_hd__decap_8
XFILLER_38_266 VGND VGND VPWR VPWR sky130_fd_sc_hd__fill_1
X_1106_ control_unit.select_time\[2\] _0498_ _0499_ net164 VGND VGND VPWR VPWR _0059_
+ sky130_fd_sc_hd__a22o_1
XFILLER_42_29 VPWR VGND VPWR VGND sky130_ef_sc_hd__decap_12
X_1037_ net118 _0452_ VGND VGND VPWR VPWR _0457_ sky130_fd_sc_hd__or2_1
XFILLER_21_155 VPWR VGND VPWR VGND sky130_ef_sc_hd__decap_12
XTAP_TAPCELL_ROW_8_148 VGND VPWR sky130_fd_sc_hd__tapvpwrvgnd_1
XFILLER_16_41 VGND VGND VPWR VPWR sky130_fd_sc_hd__fill_1
XPHY_EDGE_ROW_11_Right_11 VGND VGND VPWR VPWR sky130_fd_sc_hd__decap_3
XFILLER_12_122 VPWR VGND VPWR VGND sky130_ef_sc_hd__decap_12
XFILLER_16_63 VPWR VGND VPWR VGND sky130_ef_sc_hd__decap_12
XFILLER_16_85 VGND VGND VPWR VPWR sky130_fd_sc_hd__decap_8
XPHY_EDGE_ROW_20_Right_20 VGND VGND VPWR VPWR sky130_fd_sc_hd__decap_3
XFILLER_35_225 VPWR VGND VPWR VGND sky130_ef_sc_hd__decap_12
XTAP_TAPCELL_ROW_13_172 VGND VPWR sky130_fd_sc_hd__tapvpwrvgnd_1
X_0537_ ten_mo\[3\] VGND VGND VPWR VPWR _0092_ sky130_fd_sc_hd__inv_2
X_0606_ _0138_ _0158_ _0156_ VGND VGND VPWR VPWR net89 sky130_fd_sc_hd__a21o_1
XTAP_TAPCELL_ROW_36_286 VGND VPWR sky130_fd_sc_hd__tapvpwrvgnd_1
XTAP_TAPCELL_ROW_27_242 VGND VPWR sky130_fd_sc_hd__tapvpwrvgnd_1
XFILLER_43_72 VPWR VGND VPWR VGND sky130_ef_sc_hd__decap_12
XFILLER_4_184 VPWR VGND VPWR VGND sky130_ef_sc_hd__decap_12
XFILLER_31_261 VPWR VGND VPWR VGND sky130_ef_sc_hd__decap_12
Xclkbuf_3_2__f_clk clknet_0_clk VGND VGND VPWR VPWR clknet_3_2__leaf_clk sky130_fd_sc_hd__clkbuf_16
Xtop_century_clock_151 VGND VGND VPWR VPWR led_thou_y[1] top_century_clock_151/LO
+ sky130_fd_sc_hd__conb_1
XTAP_TAPCELL_ROW_1_110 VGND VPWR sky130_fd_sc_hd__tapvpwrvgnd_1
XFILLER_22_250 VGND VGND VPWR VPWR sky130_fd_sc_hd__fill_2
XFILLER_1_110 VGND VGND VPWR VPWR sky130_fd_sc_hd__fill_2
XFILLER_49_169 VGND VGND VPWR VPWR sky130_fd_sc_hd__fill_2
XFILLER_49_147 VGND VGND VPWR VPWR sky130_fd_sc_hd__decap_3
X_0940_ _0385_ _0389_ _0392_ VGND VGND VPWR VPWR _0393_ sky130_fd_sc_hd__nand3_1
XFILLER_20_209 VGND VGND VPWR VPWR sky130_fd_sc_hd__decap_8
X_0871_ ten_d\[0\] net135 VGND VGND VPWR VPWR _0339_ sky130_fd_sc_hd__or2_1
XTAP_TAPCELL_ROW_30_259 VGND VPWR sky130_fd_sc_hd__tapvpwrvgnd_1
XFILLER_9_276 VGND VGND VPWR VPWR sky130_fd_sc_hd__decap_4
XFILLER_48_3 VPWR VGND VPWR VGND sky130_ef_sc_hd__decap_12
XFILLER_46_139 VGND VGND VPWR VPWR sky130_fd_sc_hd__fill_1
XTAP_TAPCELL_ROW_44_329 VGND VPWR sky130_fd_sc_hd__tapvpwrvgnd_1
XFILLER_24_41 VGND VGND VPWR VPWR sky130_fd_sc_hd__decap_4
XFILLER_24_85 VGND VGND VPWR VPWR sky130_fd_sc_hd__decap_4
XFILLER_40_62 VGND VGND VPWR VPWR sky130_fd_sc_hd__fill_1
XFILLER_6_235 VPWR VGND VPWR VGND sky130_ef_sc_hd__decap_12
XFILLER_10_253 VPWR VGND VPWR VGND sky130_ef_sc_hd__decap_12
X_1070_ _0086_ _0473_ VGND VGND VPWR VPWR _0047_ sky130_fd_sc_hd__xnor2_1
X_0923_ _0374_ _0375_ _0373_ VGND VGND VPWR VPWR _0376_ sky130_fd_sc_hd__a21o_1
X_0854_ _0085_ net113 VGND VGND VPWR VPWR _0328_ sky130_fd_sc_hd__nor2_1
XPHY_EDGE_ROW_49_Right_49 VGND VGND VPWR VPWR sky130_fd_sc_hd__decap_3
X_0785_ ten_mo\[2\] _0280_ _0281_ ten_mo\[3\] VGND VGND VPWR VPWR _0283_ sky130_fd_sc_hd__o22a_1
XFILLER_28_117 VPWR VGND VPWR VGND sky130_ef_sc_hd__decap_12
X_1199_ clknet_3_4__leaf_clk _0060_ net142 VGND VGND VPWR VPWR control_unit.select_time\[4\]
+ sky130_fd_sc_hd__dfrtp_1
XFILLER_3_205 VGND VGND VPWR VPWR sky130_fd_sc_hd__decap_8
XFILLER_19_106 VGND VGND VPWR VPWR sky130_fd_sc_hd__decap_6
XFILLER_27_161 VGND VGND VPWR VPWR sky130_fd_sc_hd__decap_6
XFILLER_42_197 VPWR VGND VPWR VGND sky130_ef_sc_hd__decap_12
XFILLER_42_153 VPWR VGND VPWR VGND sky130_ef_sc_hd__decap_12
XFILLER_35_84 VGND VGND VPWR VPWR sky130_fd_sc_hd__decap_6
XFILLER_35_73 VGND VGND VPWR VPWR sky130_fd_sc_hd__decap_4
X_0570_ _0121_ _0122_ _0123_ _0124_ VGND VGND VPWR VPWR _0125_ sky130_fd_sc_hd__or4_1
X_1122_ control_unit.mode_alarm\[0\] _0507_ VGND VGND VPWR VPWR _0509_ sky130_fd_sc_hd__or2_1
X_1053_ net1 control_unit.select_time\[0\] control_unit.select_time\[5\] _0464_ VGND
+ VGND VPWR VPWR _0466_ sky130_fd_sc_hd__o2bb2a_2
X_0837_ net131 _0312_ _0315_ _0316_ VGND VGND VPWR VPWR net59 sky130_fd_sc_hd__a22o_1
X_0906_ _0196_ _0359_ _0361_ _0362_ VGND VGND VPWR VPWR top_counter.min_counter.d_u3
+ sky130_fd_sc_hd__o211a_1
X_0768_ top_counter.min_counter.ct0 net115 VGND VGND VPWR VPWR _0273_ sky130_fd_sc_hd__nand2_1
X_0699_ _0218_ _0222_ VGND VGND VPWR VPWR _0224_ sky130_fd_sc_hd__and2b_1
XFILLER_24_197 VPWR VGND VPWR VGND sky130_ef_sc_hd__decap_12
XFILLER_21_31 VPWR VGND VPWR VGND sky130_ef_sc_hd__decap_12
XFILLER_47_223 VGND VGND VPWR VPWR sky130_fd_sc_hd__fill_1
XFILLER_47_278 VGND VGND VPWR VPWR sky130_fd_sc_hd__fill_2
X_0622_ top_counter.leap_year_check.u\[1\] net129 net128 _0168_ VGND VGND VPWR VPWR
+ net95 sky130_fd_sc_hd__o31ai_1
X_0553_ ten_h\[3\] hour_counter_alarm.ten_h_alarm\[3\] VGND VGND VPWR VPWR _0108_
+ sky130_fd_sc_hd__and2b_1
X_1105_ net160 _0498_ _0499_ net168 VGND VGND VPWR VPWR _0058_ sky130_fd_sc_hd__a22o_1
XFILLER_21_167 VGND VGND VPWR VPWR sky130_fd_sc_hd__fill_1
X_1036_ net118 _0452_ VGND VGND VPWR VPWR _0456_ sky130_fd_sc_hd__nand2_1
XTAP_TAPCELL_ROW_8_149 VGND VPWR sky130_fd_sc_hd__tapvpwrvgnd_1
XFILLER_29_212 VGND VGND VPWR VPWR sky130_fd_sc_hd__fill_2
XFILLER_12_101 VGND VGND VPWR VPWR sky130_fd_sc_hd__fill_1
XFILLER_16_75 VGND VGND VPWR VPWR sky130_fd_sc_hd__decap_8
XFILLER_32_85 VPWR VGND VPWR VGND sky130_ef_sc_hd__decap_12
XFILLER_32_41 VPWR VGND VPWR VGND sky130_ef_sc_hd__decap_12
XFILLER_8_116 VGND VGND VPWR VPWR sky130_fd_sc_hd__fill_2
XFILLER_8_138 VGND VGND VPWR VPWR sky130_fd_sc_hd__fill_2
XFILLER_35_237 VPWR VGND VPWR VGND sky130_ef_sc_hd__decap_12
XTAP_TAPCELL_ROW_13_173 VGND VPWR sky130_fd_sc_hd__tapvpwrvgnd_1
X_0536_ net123 VGND VGND VPWR VPWR _0091_ sky130_fd_sc_hd__inv_2
X_0605_ _0154_ _0157_ VGND VGND VPWR VPWR _0158_ sky130_fd_sc_hd__and2b_1
XFILLER_41_229 VGND VGND VPWR VPWR sky130_fd_sc_hd__fill_2
X_1019_ min_counter_alarm.ten_m_alarm\[1\] min_counter_alarm.ten_m_alarm\[3\] min_counter_alarm.ten_m_alarm\[2\]
+ min_counter_alarm.ten_m_alarm\[0\] VGND VGND VPWR VPWR _0443_ sky130_fd_sc_hd__or4bb_1
XFILLER_26_237 VPWR VGND VPWR VGND sky130_ef_sc_hd__decap_12
XTAP_TAPCELL_ROW_36_287 VGND VPWR sky130_fd_sc_hd__tapvpwrvgnd_1
XFILLER_5_119 VGND VGND VPWR VPWR sky130_fd_sc_hd__fill_1
XFILLER_27_30 VPWR VGND VPWR VGND sky130_ef_sc_hd__decap_12
XFILLER_43_51 VGND VGND VPWR VPWR sky130_fd_sc_hd__decap_4
XFILLER_25_281 VGND VGND VPWR VPWR sky130_fd_sc_hd__decap_8
XTAP_TAPCELL_ROW_27_243 VGND VPWR sky130_fd_sc_hd__tapvpwrvgnd_1
XFILLER_43_84 VPWR VGND VPWR VGND sky130_ef_sc_hd__decap_12
XFILLER_31_273 VGND VGND VPWR VPWR sky130_fd_sc_hd__decap_6
Xtop_century_clock_152 VGND VGND VPWR VPWR led_thou_y[4] top_century_clock_152/LO
+ sky130_fd_sc_hd__conb_1
XFILLER_48_29 VPWR VGND VPWR VGND sky130_ef_sc_hd__decap_12
XTAP_TAPCELL_ROW_1_111 VGND VPWR sky130_fd_sc_hd__tapvpwrvgnd_1
X_0519_ hour_counter_alarm.ten_h_alarm\[2\] VGND VGND VPWR VPWR _0074_ sky130_fd_sc_hd__inv_2
XFILLER_22_273 VGND VGND VPWR VPWR sky130_fd_sc_hd__fill_1
XFILLER_49_126 VGND VGND VPWR VPWR sky130_fd_sc_hd__decap_3
XFILLER_8_3 VPWR VGND VPWR VGND sky130_ef_sc_hd__decap_12
X_0870_ ten_d\[0\] net135 net134 VGND VGND VPWR VPWR _0338_ sky130_fd_sc_hd__nand3_1
XFILLER_13_262 VPWR VGND VPWR VGND sky130_ef_sc_hd__decap_12
XFILLER_48_181 VPWR VGND VPWR VGND sky130_ef_sc_hd__decap_12
X_0999_ _0289_ _0401_ _0426_ _0430_ VGND VGND VPWR VPWR _0021_ sky130_fd_sc_hd__o31ai_1
XFILLER_46_129 VGND VGND VPWR VPWR sky130_fd_sc_hd__fill_1
XFILLER_6_203 VGND VGND VPWR VPWR sky130_fd_sc_hd__fill_1
XFILLER_6_247 VGND VGND VPWR VPWR sky130_fd_sc_hd__decap_4
XFILLER_10_265 VPWR VGND VPWR VGND sky130_ef_sc_hd__decap_12
X_0853_ _0322_ _0324_ _0327_ _0326_ VGND VGND VPWR VPWR net47 sky130_fd_sc_hd__a31o_1
X_0922_ top_counter.day_in_month_decode.unit_mo\[0\] top_counter.day_in_month_decode.unit_mo\[1\]
+ net125 net124 VGND VGND VPWR VPWR _0375_ sky130_fd_sc_hd__or4b_1
X_0784_ ten_mo\[3\] _0281_ VGND VGND VPWR VPWR _0282_ sky130_fd_sc_hd__nor2_1
Xinput1 inc VGND VGND VPWR VPWR net1 sky130_fd_sc_hd__buf_2
X_1198_ clknet_3_4__leaf_clk _0059_ net142 VGND VGND VPWR VPWR control_unit.select_time\[3\]
+ sky130_fd_sc_hd__dfrtp_1
XFILLER_28_129 VGND VGND VPWR VPWR sky130_fd_sc_hd__decap_8
XFILLER_36_195 VGND VGND VPWR VPWR sky130_fd_sc_hd__fill_1
XFILLER_42_165 VGND VGND VPWR VPWR sky130_fd_sc_hd__decap_8
XFILLER_32_7 VPWR VGND VPWR VGND sky130_ef_sc_hd__decap_12
XPHY_EDGE_ROW_27_Left_77 VGND VGND VPWR VPWR sky130_fd_sc_hd__decap_3
X_1052_ _0464_ VGND VGND VPWR VPWR _0465_ sky130_fd_sc_hd__inv_2
X_1121_ _0507_ VGND VGND VPWR VPWR _0508_ sky130_fd_sc_hd__inv_2
X_0836_ net131 net130 VGND VGND VPWR VPWR _0316_ sky130_fd_sc_hd__nor2_1
X_0905_ net116 _0190_ _0357_ top_counter.min_counter.u3 VGND VGND VPWR VPWR _0362_
+ sky130_fd_sc_hd__a31o_1
X_0767_ _0263_ _0272_ VGND VGND VPWR VPWR net31 sky130_fd_sc_hd__nor2_1
X_0698_ _0219_ _0223_ VGND VGND VPWR VPWR net67 sky130_fd_sc_hd__xor2_1
XFILLER_0_209 VGND VGND VPWR VPWR sky130_fd_sc_hd__decap_4
XFILLER_21_43 VPWR VGND VPWR VGND sky130_ef_sc_hd__decap_12
XFILLER_47_202 VGND VGND VPWR VPWR sky130_fd_sc_hd__fill_2
XFILLER_46_95 VGND VGND VPWR VPWR sky130_fd_sc_hd__decap_6
XFILLER_15_110 VGND VGND VPWR VPWR sky130_fd_sc_hd__fill_2
XFILLER_15_198 VGND VGND VPWR VPWR sky130_fd_sc_hd__fill_1
X_0621_ net129 _0165_ _0166_ net128 VGND VGND VPWR VPWR _0168_ sky130_fd_sc_hd__o22ai_1
XFILLER_7_23 VGND VGND VPWR VPWR sky130_fd_sc_hd__decap_3
X_0552_ _0099_ _0100_ _0101_ _0106_ VGND VGND VPWR VPWR _0107_ sky130_fd_sc_hd__or4_1
XFILLER_23_3 VPWR VGND VPWR VGND sky130_ef_sc_hd__decap_12
X_1104_ net159 _0498_ _0499_ net160 VGND VGND VPWR VPWR _0057_ sky130_fd_sc_hd__a22o_1
X_1035_ _0070_ _0071_ _0454_ VGND VGND VPWR VPWR _0455_ sky130_fd_sc_hd__and3_1
XFILLER_21_113 VGND VGND VPWR VPWR sky130_fd_sc_hd__decap_8
X_0819_ hun_y\[2\] _0295_ hun_y\[3\] VGND VGND VPWR VPWR _0304_ sky130_fd_sc_hd__o21ai_1
XFILLER_29_279 VGND VGND VPWR VPWR sky130_fd_sc_hd__fill_1
XFILLER_32_97 VPWR VGND VPWR VGND sky130_ef_sc_hd__decap_12
XFILLER_32_53 VPWR VGND VPWR VGND sky130_ef_sc_hd__decap_12
XFILLER_35_249 VPWR VGND VPWR VGND sky130_ef_sc_hd__decap_12
XFILLER_35_205 VPWR VGND VPWR VGND sky130_ef_sc_hd__decap_12
XTAP_TAPCELL_ROW_13_174 VGND VPWR sky130_fd_sc_hd__tapvpwrvgnd_1
XFILLER_7_150 VPWR VGND VPWR VGND sky130_ef_sc_hd__decap_12
XPHY_EDGE_ROW_9_Right_9 VGND VGND VPWR VPWR sky130_fd_sc_hd__decap_3
X_0604_ top_counter.second_counter.unit_s\[0\] top_counter.second_counter.unit_s\[1\]
+ net104 VGND VGND VPWR VPWR _0157_ sky130_fd_sc_hd__or3_1
X_0535_ net124 VGND VGND VPWR VPWR _0090_ sky130_fd_sc_hd__inv_2
XTAP_TAPCELL_ROW_36_288 VGND VPWR sky130_fd_sc_hd__tapvpwrvgnd_1
X_1018_ min_counter_alarm.ten_m_alarm\[0\] _0440_ _0442_ VGND VGND VPWR VPWR _0028_
+ sky130_fd_sc_hd__a21bo_1
XPHY_EDGE_ROW_14_Left_64 VGND VGND VPWR VPWR sky130_fd_sc_hd__decap_3
XFILLER_26_249 VGND VGND VPWR VPWR sky130_fd_sc_hd__decap_3
XFILLER_27_42 VGND VGND VPWR VPWR sky130_fd_sc_hd__fill_1
XFILLER_43_96 VGND VGND VPWR VPWR sky130_fd_sc_hd__decap_6
XTAP_TAPCELL_ROW_27_244 VGND VPWR sky130_fd_sc_hd__tapvpwrvgnd_1
XTAP_TAPCELL_ROW_10_155 VGND VPWR sky130_fd_sc_hd__tapvpwrvgnd_1
XFILLER_4_197 VGND VGND VPWR VPWR sky130_fd_sc_hd__decap_4
X_0518_ ten_h\[1\] VGND VGND VPWR VPWR _0073_ sky130_fd_sc_hd__inv_2
XTAP_TAPCELL_ROW_1_112 VGND VPWR sky130_fd_sc_hd__tapvpwrvgnd_1
Xtop_century_clock_153 VGND VGND VPWR VPWR led_am_pm[4] top_century_clock_153/LO sky130_fd_sc_hd__conb_1
XFILLER_22_230 VPWR VGND VPWR VGND sky130_ef_sc_hd__decap_12
XTAP_TAPCELL_ROW_24_225 VGND VPWR sky130_fd_sc_hd__tapvpwrvgnd_1
XFILLER_13_44 VPWR VGND VPWR VGND sky130_ef_sc_hd__decap_12
XFILLER_13_66 VPWR VGND VPWR VGND sky130_ef_sc_hd__decap_12
XFILLER_49_105 VGND VGND VPWR VPWR sky130_fd_sc_hd__decap_3
XFILLER_1_167 VGND VGND VPWR VPWR sky130_fd_sc_hd__fill_1
XFILLER_1_189 VPWR VGND VPWR VGND sky130_ef_sc_hd__decap_12
XFILLER_13_274 VGND VGND VPWR VPWR sky130_fd_sc_hd__decap_6
XFILLER_48_193 VGND VGND VPWR VPWR sky130_fd_sc_hd__decap_3
X_0998_ _0423_ _0425_ net123 VGND VGND VPWR VPWR _0430_ sky130_fd_sc_hd__a21bo_1
XFILLER_10_277 VPWR VGND VPWR VGND sky130_ef_sc_hd__decap_12
XFILLER_1_47 VGND VGND VPWR VPWR sky130_fd_sc_hd__fill_2
XTAP_TAPCELL_ROW_43_320 VGND VPWR sky130_fd_sc_hd__tapvpwrvgnd_1
X_0921_ top_counter.day_in_month_decode.unit_mo\[3\] top_counter.day_in_month_decode.unit_mo\[0\]
+ VGND VGND VPWR VPWR _0374_ sky130_fd_sc_hd__nand2b_1
X_0783_ ten_mo\[1\] ten_mo\[0\] VGND VGND VPWR VPWR _0281_ sky130_fd_sc_hd__and2_1
X_0852_ net114 net113 VGND VGND VPWR VPWR _0327_ sky130_fd_sc_hd__or2_1
XFILLER_5_281 VPWR VGND VPWR VGND sky130_ef_sc_hd__decap_12
XFILLER_36_141 VPWR VGND VPWR VGND sky130_ef_sc_hd__decap_12
Xinput2 mode VGND VGND VPWR VPWR net2 sky130_fd_sc_hd__buf_1
X_1197_ clknet_3_1__leaf_clk _0058_ net137 VGND VGND VPWR VPWR control_unit.select_time\[2\]
+ sky130_fd_sc_hd__dfrtp_2
XFILLER_10_67 VPWR VGND VPWR VGND sky130_ef_sc_hd__decap_12
XFILLER_19_43 VGND VGND VPWR VPWR sky130_fd_sc_hd__fill_1
XFILLER_19_65 VGND VGND VPWR VPWR sky130_fd_sc_hd__decap_8
XPHY_EDGE_ROW_2_Left_52 VGND VGND VPWR VPWR sky130_fd_sc_hd__decap_3
XFILLER_2_251 VGND VGND VPWR VPWR sky130_fd_sc_hd__fill_1
XFILLER_25_7 VGND VGND VPWR VPWR sky130_fd_sc_hd__fill_1
XFILLER_33_100 VPWR VGND VPWR VGND sky130_ef_sc_hd__decap_12
X_1120_ control_unit.current_state\[0\] net4 VGND VGND VPWR VPWR _0507_ sky130_fd_sc_hd__and2b_1
XFILLER_18_141 VPWR VGND VPWR VGND sky130_ef_sc_hd__decap_12
X_1051_ control_unit.select_time\[2\] control_unit.select_time\[3\] control_unit.select_time\[4\]
+ _0354_ VGND VGND VPWR VPWR _0464_ sky130_fd_sc_hd__or4_1
X_0904_ _0357_ _0358_ VGND VGND VPWR VPWR _0361_ sky130_fd_sc_hd__nand2_1
X_0835_ _0088_ ten_y\[1\] VGND VGND VPWR VPWR _0315_ sky130_fd_sc_hd__nor2_1
X_0766_ _0260_ _0264_ VGND VGND VPWR VPWR _0272_ sky130_fd_sc_hd__xnor2_1
X_0697_ _0210_ _0214_ _0222_ VGND VGND VPWR VPWR _0223_ sky130_fd_sc_hd__o21ba_1
XPHY_EDGE_ROW_44_Left_94 VGND VGND VPWR VPWR sky130_fd_sc_hd__decap_3
XFILLER_21_55 VGND VGND VPWR VPWR sky130_fd_sc_hd__fill_1
XFILLER_46_74 VGND VGND VPWR VPWR sky130_fd_sc_hd__fill_1
XFILLER_46_41 VGND VGND VPWR VPWR sky130_fd_sc_hd__decap_4
XFILLER_15_133 VGND VGND VPWR VPWR sky130_fd_sc_hd__decap_3
X_0620_ _0166_ VGND VGND VPWR VPWR _0167_ sky130_fd_sc_hd__inv_2
X_0551_ _0102_ _0103_ _0104_ _0105_ VGND VGND VPWR VPWR _0106_ sky130_fd_sc_hd__or4_1
X_1103_ _0465_ _0498_ _0499_ net159 VGND VGND VPWR VPWR _0056_ sky130_fd_sc_hd__a22o_1
X_1034_ top_counter.hour_counter.unit_h\[0\] top_counter.hour_counter.unit_h\[3\]
+ _0451_ VGND VGND VPWR VPWR _0454_ sky130_fd_sc_hd__and3_1
XFILLER_21_169 VGND VGND VPWR VPWR sky130_fd_sc_hd__decap_6
X_0818_ net17 _0303_ _0300_ VGND VGND VPWR VPWR net14 sky130_fd_sc_hd__nand3b_1
X_0749_ _0253_ _0254_ ten_h\[0\] VGND VGND VPWR VPWR _0261_ sky130_fd_sc_hd__a21o_1
XTAP_TAPCELL_ROW_7_140 VGND VPWR sky130_fd_sc_hd__tapvpwrvgnd_1
XFILLER_35_217 VGND VGND VPWR VPWR sky130_fd_sc_hd__decap_6
XFILLER_11_180 VGND VGND VPWR VPWR sky130_fd_sc_hd__decap_3
XFILLER_7_162 VGND VGND VPWR VPWR sky130_fd_sc_hd__decap_6
X_0603_ _0154_ _0155_ VGND VGND VPWR VPWR _0156_ sky130_fd_sc_hd__and2_1
X_0534_ net127 VGND VGND VPWR VPWR _0089_ sky130_fd_sc_hd__inv_2
XFILLER_26_217 VGND VGND VPWR VPWR sky130_fd_sc_hd__fill_2
XTAP_TAPCELL_ROW_36_289 VGND VPWR sky130_fd_sc_hd__tapvpwrvgnd_1
X_1017_ min_counter_alarm.ten_m_alarm\[0\] net5 _0439_ VGND VGND VPWR VPWR _0442_
+ sky130_fd_sc_hd__or3b_1
XFILLER_19_291 VGND VGND VPWR VPWR sky130_fd_sc_hd__fill_1
XFILLER_32_209 VPWR VGND VPWR VGND sky130_ef_sc_hd__decap_12
XFILLER_40_253 VPWR VGND VPWR VGND sky130_ef_sc_hd__decap_12
XTAP_TAPCELL_ROW_10_156 VGND VPWR sky130_fd_sc_hd__tapvpwrvgnd_1
XPHY_EDGE_ROW_31_Left_81 VGND VGND VPWR VPWR sky130_fd_sc_hd__decap_3
XFILLER_31_220 VGND VGND VPWR VPWR sky130_fd_sc_hd__decap_4
X_0517_ ten_h\[0\] VGND VGND VPWR VPWR _0072_ sky130_fd_sc_hd__inv_2
XTAP_TAPCELL_ROW_1_113 VGND VPWR sky130_fd_sc_hd__tapvpwrvgnd_1
XFILLER_22_242 VGND VGND VPWR VPWR sky130_fd_sc_hd__decap_8
XFILLER_22_253 VPWR VGND VPWR VGND sky130_ef_sc_hd__decap_12
XTAP_TAPCELL_ROW_24_226 VGND VPWR sky130_fd_sc_hd__tapvpwrvgnd_1
XFILLER_13_78 VPWR VGND VPWR VGND sky130_ef_sc_hd__decap_12
XFILLER_13_220 VGND VGND VPWR VPWR sky130_fd_sc_hd__decap_4
X_0997_ ten_mo\[0\] _0426_ VGND VGND VPWR VPWR _0020_ sky130_fd_sc_hd__xnor2_1
XFILLER_10_289 VGND VGND VPWR VPWR sky130_fd_sc_hd__decap_6
XFILLER_24_66 VGND VGND VPWR VPWR sky130_fd_sc_hd__decap_4
XFILLER_49_63 VGND VGND VPWR VPWR sky130_fd_sc_hd__decap_3
XFILLER_49_41 VGND VGND VPWR VPWR sky130_fd_sc_hd__decap_8
XFILLER_49_85 VGND VGND VPWR VPWR sky130_fd_sc_hd__fill_2
XFILLER_1_15 VPWR VGND VPWR VGND sky130_ef_sc_hd__decap_12
XTAP_TAPCELL_ROW_43_321 VGND VPWR sky130_fd_sc_hd__tapvpwrvgnd_1
X_0920_ net123 ten_mo\[0\] ten_mo\[3\] ten_mo\[2\] VGND VGND VPWR VPWR _0373_ sky130_fd_sc_hd__or4_1
X_0782_ _0091_ ten_mo\[0\] VGND VGND VPWR VPWR _0280_ sky130_fd_sc_hd__nor2_1
X_0851_ ten_s\[3\] net112 net104 VGND VGND VPWR VPWR _0326_ sky130_fd_sc_hd__a21o_1
XFILLER_46_3 VPWR VGND VPWR VGND sky130_ef_sc_hd__decap_12
XPHY_EDGE_ROW_18_Right_18 VGND VGND VPWR VPWR sky130_fd_sc_hd__decap_3
XFILLER_36_197 VPWR VGND VPWR VGND sky130_ef_sc_hd__decap_12
XFILLER_36_153 VPWR VGND VPWR VGND sky130_ef_sc_hd__decap_12
Xinput3 reset_n VGND VGND VPWR VPWR net3 sky130_fd_sc_hd__clkbuf_1
X_1196_ clknet_3_1__leaf_clk _0057_ net137 VGND VGND VPWR VPWR control_unit.select_time\[1\]
+ sky130_fd_sc_hd__dfrtp_1
XPHY_EDGE_ROW_27_Right_27 VGND VGND VPWR VPWR sky130_fd_sc_hd__decap_3
XPHY_EDGE_ROW_36_Right_36 VGND VGND VPWR VPWR sky130_fd_sc_hd__decap_3
XFILLER_10_79 VGND VGND VPWR VPWR sky130_fd_sc_hd__decap_4
XFILLER_19_55 VGND VGND VPWR VPWR sky130_fd_sc_hd__fill_1
XPHY_EDGE_ROW_45_Right_45 VGND VGND VPWR VPWR sky130_fd_sc_hd__decap_3
XFILLER_42_101 VGND VGND VPWR VPWR sky130_fd_sc_hd__decap_4
X_1050_ net158 _0462_ VGND VGND VPWR VPWR _0039_ sky130_fd_sc_hd__xor2_1
XFILLER_18_153 VGND VGND VPWR VPWR sky130_fd_sc_hd__decap_4
XFILLER_18_197 VGND VGND VPWR VPWR sky130_fd_sc_hd__decap_8
X_0834_ ten_y\[0\] _0313_ _0314_ net131 VGND VGND VPWR VPWR net55 sky130_fd_sc_hd__a22o_1
XFILLER_33_167 VGND VGND VPWR VPWR sky130_fd_sc_hd__fill_1
X_0903_ net116 _0359_ VGND VGND VPWR VPWR top_counter.min_counter.d_u2 sky130_fd_sc_hd__xnor2_1
X_0765_ _0252_ _0260_ _0268_ VGND VGND VPWR VPWR net30 sky130_fd_sc_hd__o21ai_1
X_0696_ _0076_ net108 _0221_ VGND VGND VPWR VPWR _0222_ sky130_fd_sc_hd__a21oi_4
X_1179_ clknet_3_1__leaf_clk _0040_ net137 VGND VGND VPWR VPWR top_counter.second_counter.unit_s\[0\]
+ sky130_fd_sc_hd__dfrtp_4
XFILLER_30_104 VPWR VGND VPWR VGND sky130_ef_sc_hd__decap_12
XFILLER_15_156 VPWR VGND VPWR VGND sky130_ef_sc_hd__decap_12
X_0550_ net118 hour_counter_alarm.unit_h_alarm\[1\] VGND VGND VPWR VPWR _0105_ sky130_fd_sc_hd__and2b_1
XFILLER_38_237 VPWR VGND VPWR VGND sky130_ef_sc_hd__decap_12
X_1102_ _0498_ control_unit.current_state\[0\] VGND VGND VPWR VPWR _0499_ sky130_fd_sc_hd__and2b_1
X_1033_ _0452_ _0453_ VGND VGND VPWR VPWR _0032_ sky130_fd_sc_hd__nor2_1
X_0817_ hun_y\[2\] _0295_ VGND VGND VPWR VPWR _0303_ sky130_fd_sc_hd__nand2_1
X_0748_ _0074_ net105 _0258_ VGND VGND VPWR VPWR _0260_ sky130_fd_sc_hd__a21bo_2
X_0679_ ten_h\[0\] ten_h\[1\] ten_h\[2\] ten_h\[3\] VGND VGND VPWR VPWR _0205_ sky130_fd_sc_hd__a211oi_2
XFILLER_37_281 VGND VGND VPWR VPWR sky130_fd_sc_hd__decap_8
XPHY_EDGE_ROW_0_Right_0 VGND VGND VPWR VPWR sky130_fd_sc_hd__decap_3
XFILLER_8_108 VGND VGND VPWR VPWR sky130_fd_sc_hd__decap_8
XTAP_TAPCELL_ROW_7_141 VGND VPWR sky130_fd_sc_hd__tapvpwrvgnd_1
X_0533_ ten_y\[0\] VGND VGND VPWR VPWR _0088_ sky130_fd_sc_hd__inv_2
X_0602_ top_counter.second_counter.unit_s\[2\] net104 VGND VGND VPWR VPWR _0155_ sky130_fd_sc_hd__or2_1
XFILLER_34_251 VGND VGND VPWR VPWR sky130_fd_sc_hd__fill_1
X_1016_ net107 _0438_ VGND VGND VPWR VPWR _0441_ sky130_fd_sc_hd__nor2_1
XFILLER_25_273 VGND VGND VPWR VPWR sky130_fd_sc_hd__decap_6
XFILLER_43_65 VGND VGND VPWR VPWR sky130_fd_sc_hd__fill_1
XFILLER_40_265 VGND VGND VPWR VPWR sky130_fd_sc_hd__fill_1
XTAP_TAPCELL_ROW_10_157 VGND VPWR sky130_fd_sc_hd__tapvpwrvgnd_1
XFILLER_4_155 VGND VGND VPWR VPWR sky130_fd_sc_hd__fill_2
XFILLER_4_144 VGND VGND VPWR VPWR sky130_fd_sc_hd__fill_1
XFILLER_4_37 VGND VGND VPWR VPWR sky130_fd_sc_hd__fill_1
XFILLER_4_15 VPWR VGND VPWR VGND sky130_ef_sc_hd__decap_12
XFILLER_16_251 VGND VGND VPWR VPWR sky130_fd_sc_hd__fill_1
X_0516_ top_counter.hour_counter.unit_h\[2\] VGND VGND VPWR VPWR _0071_ sky130_fd_sc_hd__inv_2
XTAP_TAPCELL_ROW_1_114 VGND VPWR sky130_fd_sc_hd__tapvpwrvgnd_1
XFILLER_13_57 VGND VGND VPWR VPWR sky130_fd_sc_hd__decap_4
XFILLER_22_265 VGND VGND VPWR VPWR sky130_fd_sc_hd__decap_8
XTAP_TAPCELL_ROW_24_227 VGND VPWR sky130_fd_sc_hd__tapvpwrvgnd_1
XFILLER_9_225 VPWR VGND VPWR VGND sky130_ef_sc_hd__decap_12
X_0996_ _0090_ _0427_ _0429_ _0423_ VGND VGND VPWR VPWR _0019_ sky130_fd_sc_hd__a22oi_1
XFILLER_24_45 VGND VGND VPWR VPWR sky130_fd_sc_hd__fill_1
XFILLER_6_3 VPWR VGND VPWR VGND sky130_ef_sc_hd__decap_12
XFILLER_1_27 VPWR VGND VPWR VGND sky130_ef_sc_hd__decap_12
XTAP_TAPCELL_ROW_43_322 VGND VPWR sky130_fd_sc_hd__tapvpwrvgnd_1
X_0850_ ten_s\[3\] net104 VGND VGND VPWR VPWR _0325_ sky130_fd_sc_hd__or2_1
X_0781_ _0276_ top_counter.min_counter.t2 _0273_ VGND VGND VPWR VPWR net37 sky130_fd_sc_hd__and3b_1
Xinput4 sel VGND VGND VPWR VPWR net4 sky130_fd_sc_hd__buf_1
XFILLER_36_165 VPWR VGND VPWR VGND sky130_ef_sc_hd__decap_12
XFILLER_36_132 VGND VGND VPWR VPWR sky130_fd_sc_hd__decap_8
X_1195_ clknet_3_1__leaf_clk _0056_ net137 VGND VGND VPWR VPWR control_unit.select_time\[0\]
+ sky130_fd_sc_hd__dfrtp_1
X_0979_ _0165_ _0174_ _0403_ VGND VGND VPWR VPWR _0419_ sky130_fd_sc_hd__o21ba_1
XFILLER_10_47 VGND VGND VPWR VPWR sky130_fd_sc_hd__fill_1
XFILLER_35_55 VGND VGND VPWR VPWR sky130_fd_sc_hd__fill_1
XFILLER_2_253 VPWR VGND VPWR VGND sky130_ef_sc_hd__decap_12
XFILLER_33_113 VPWR VGND VPWR VGND sky130_ef_sc_hd__decap_12
X_0833_ net130 ten_y\[1\] VGND VGND VPWR VPWR _0314_ sky130_fd_sc_hd__nand2b_1
X_0902_ top_counter.min_counter.u1 _0357_ _0360_ VGND VGND VPWR VPWR top_counter.min_counter.d_u1
+ sky130_fd_sc_hd__o21ba_1
X_0764_ _0252_ _0270_ _0271_ VGND VGND VPWR VPWR net29 sky130_fd_sc_hd__mux2_1
X_0695_ net105 _0216_ _0220_ VGND VGND VPWR VPWR _0221_ sky130_fd_sc_hd__and3b_1
X_1178_ clknet_3_2__leaf_clk top_counter.min_counter.d_u0 net139 VGND VGND VPWR VPWR
+ top_counter.min_counter.c0 sky130_fd_sc_hd__dfrtp_4
XFILLER_21_57 VPWR VGND VPWR VGND sky130_ef_sc_hd__decap_12
XFILLER_15_113 VPWR VGND VPWR VGND sky130_ef_sc_hd__decap_12
XFILLER_30_116 VPWR VGND VPWR VGND sky130_ef_sc_hd__decap_12
XFILLER_7_15 VGND VGND VPWR VPWR sky130_fd_sc_hd__decap_8
XFILLER_30_7 VGND VGND VPWR VPWR sky130_fd_sc_hd__decap_6
XFILLER_38_249 VGND VGND VPWR VPWR sky130_fd_sc_hd__decap_3
X_1101_ control_unit.current_state\[1\] net4 control_unit.current_state\[0\] VGND
+ VGND VPWR VPWR _0498_ sky130_fd_sc_hd__and3b_2
X_1032_ top_counter.hour_counter.unit_h\[0\] _0451_ VGND VGND VPWR VPWR _0453_ sky130_fd_sc_hd__nor2_1
XTAP_TAPCELL_ROW_16_185 VGND VPWR sky130_fd_sc_hd__tapvpwrvgnd_1
X_0816_ _0096_ _0298_ _0302_ VGND VGND VPWR VPWR net17 sky130_fd_sc_hd__o21bai_1
X_0747_ _0074_ net105 _0258_ VGND VGND VPWR VPWR _0259_ sky130_fd_sc_hd__a21boi_1
X_0678_ _0072_ _0073_ VGND VGND VPWR VPWR _0204_ sky130_fd_sc_hd__nor2_1
XFILLER_20_160 VPWR VGND VPWR VGND sky130_ef_sc_hd__decap_12
XTAP_TAPCELL_ROW_7_142 VGND VPWR sky130_fd_sc_hd__tapvpwrvgnd_1
XFILLER_7_131 VGND VGND VPWR VPWR sky130_fd_sc_hd__decap_3
X_0601_ top_counter.second_counter.unit_s\[3\] _0153_ VGND VGND VPWR VPWR _0154_ sky130_fd_sc_hd__or2_1
X_0532_ control_unit.select_time\[2\] VGND VGND VPWR VPWR _0087_ sky130_fd_sc_hd__inv_2
X_1015_ net107 _0439_ VGND VGND VPWR VPWR _0440_ sky130_fd_sc_hd__nor2_1
XFILLER_43_55 VGND VGND VPWR VPWR sky130_fd_sc_hd__fill_1
XTAP_TAPCELL_ROW_35_280 VGND VPWR sky130_fd_sc_hd__tapvpwrvgnd_1
XFILLER_4_112 VPWR VGND VPWR VGND sky130_ef_sc_hd__decap_12
XTAP_TAPCELL_ROW_10_158 VGND VPWR sky130_fd_sc_hd__tapvpwrvgnd_1
XFILLER_4_49 VGND VGND VPWR VPWR sky130_fd_sc_hd__fill_1
XFILLER_4_27 VGND VGND VPWR VPWR sky130_fd_sc_hd__fill_1
XFILLER_31_288 VGND VGND VPWR VPWR sky130_fd_sc_hd__decap_4
XPHY_EDGE_ROW_18_Left_68 VGND VGND VPWR VPWR sky130_fd_sc_hd__decap_3
XTAP_TAPCELL_ROW_49_350 VGND VPWR sky130_fd_sc_hd__tapvpwrvgnd_1
X_0515_ net118 VGND VGND VPWR VPWR _0070_ sky130_fd_sc_hd__inv_2
XTAP_TAPCELL_ROW_24_228 VGND VPWR sky130_fd_sc_hd__tapvpwrvgnd_1
XFILLER_49_119 VGND VGND VPWR VPWR sky130_fd_sc_hd__decap_3
XFILLER_9_237 VGND VGND VPWR VPWR sky130_fd_sc_hd__decap_6
XFILLER_48_141 VPWR VGND VPWR VGND sky130_ef_sc_hd__decap_12
X_0995_ _0178_ _0428_ _0377_ VGND VGND VPWR VPWR _0429_ sky130_fd_sc_hd__a21bo_1
XFILLER_5_81 VPWR VGND VPWR VGND sky130_ef_sc_hd__decap_12
XFILLER_39_163 VGND VGND VPWR VPWR sky130_fd_sc_hd__decap_4
XFILLER_39_130 VPWR VGND VPWR VGND sky130_ef_sc_hd__decap_12
XFILLER_40_56 VGND VGND VPWR VPWR sky130_fd_sc_hd__decap_6
XFILLER_10_247 VGND VGND VPWR VPWR sky130_fd_sc_hd__decap_4
XFILLER_49_98 VGND VGND VPWR VPWR sky130_fd_sc_hd__decap_3
XFILLER_45_166 VGND VGND VPWR VPWR sky130_fd_sc_hd__fill_2
XFILLER_45_122 VPWR VGND VPWR VGND sky130_ef_sc_hd__decap_12
XFILLER_45_100 VGND VGND VPWR VPWR sky130_fd_sc_hd__fill_1
XTAP_TAPCELL_ROW_43_323 VGND VPWR sky130_fd_sc_hd__tapvpwrvgnd_1
XFILLER_1_39 VGND VGND VPWR VPWR sky130_fd_sc_hd__decap_8
X_0780_ net117 _0279_ VGND VGND VPWR VPWR net36 sky130_fd_sc_hd__and2b_1
XFILLER_5_262 VGND VGND VPWR VPWR sky130_fd_sc_hd__fill_1
XFILLER_5_240 VGND VGND VPWR VPWR sky130_fd_sc_hd__decap_6
X_1194_ clknet_3_3__leaf_clk _0055_ net139 VGND VGND VPWR VPWR min_counter_alarm.unit_m_alarm\[3\]
+ sky130_fd_sc_hd__dfrtp_1
XFILLER_36_177 VPWR VGND VPWR VGND sky130_ef_sc_hd__decap_12
X_0978_ top_counter.leap_year_check.u\[0\] net102 VGND VGND VPWR VPWR _0012_ sky130_fd_sc_hd__xor2_1
XFILLER_10_15 VPWR VGND VPWR VGND sky130_ef_sc_hd__decap_12
XFILLER_19_35 VGND VGND VPWR VPWR sky130_fd_sc_hd__decap_8
XFILLER_27_111 VGND VGND VPWR VPWR sky130_fd_sc_hd__fill_1
XFILLER_2_265 VPWR VGND VPWR VGND sky130_ef_sc_hd__decap_12
XFILLER_33_169 VPWR VGND VPWR VGND sky130_ef_sc_hd__decap_12
XFILLER_33_125 VPWR VGND VPWR VGND sky130_ef_sc_hd__decap_12
XFILLER_18_188 VGND VGND VPWR VPWR sky130_fd_sc_hd__decap_8
X_0832_ ten_y\[1\] net130 VGND VGND VPWR VPWR _0313_ sky130_fd_sc_hd__nand2_1
X_0901_ _0190_ _0197_ _0358_ _0357_ VGND VGND VPWR VPWR _0360_ sky130_fd_sc_hd__o31a_1
X_0763_ _0259_ _0261_ VGND VGND VPWR VPWR _0271_ sky130_fd_sc_hd__or2_1
X_0694_ top_counter.hour_counter.unit_h\[1\] _0207_ top_counter.hour_counter.unit_h\[2\]
+ VGND VGND VPWR VPWR _0220_ sky130_fd_sc_hd__o21ai_1
X_1177_ clknet_3_0__leaf_clk top_counter.min_counter.d_t1 net136 VGND VGND VPWR VPWR
+ top_counter.min_counter.t1 sky130_fd_sc_hd__dfrtp_1
XFILLER_21_69 VPWR VGND VPWR VGND sky130_ef_sc_hd__decap_12
XPHY_EDGE_ROW_6_Left_56 VGND VGND VPWR VPWR sky130_fd_sc_hd__decap_3
XFILLER_46_66 VGND VGND VPWR VPWR sky130_fd_sc_hd__fill_1
XFILLER_30_128 VPWR VGND VPWR VGND sky130_ef_sc_hd__decap_12
XFILLER_15_125 VGND VGND VPWR VPWR sky130_fd_sc_hd__decap_8
XFILLER_15_169 VGND VGND VPWR VPWR sky130_fd_sc_hd__decap_6
X_1100_ _0437_ _0441_ _0497_ _0491_ net166 VGND VGND VPWR VPWR _0055_ sky130_fd_sc_hd__a32o_1
X_1031_ top_counter.hour_counter.unit_h\[0\] _0451_ VGND VGND VPWR VPWR _0452_ sky130_fd_sc_hd__and2_1
XTAP_TAPCELL_ROW_16_186 VGND VPWR sky130_fd_sc_hd__tapvpwrvgnd_1
X_0815_ hun_y\[3\] hun_y\[2\] _0301_ VGND VGND VPWR VPWR _0302_ sky130_fd_sc_hd__nor3_1
X_0746_ net105 _0250_ _0257_ VGND VGND VPWR VPWR _0258_ sky130_fd_sc_hd__or3_1
XPHY_EDGE_ROW_48_Left_98 VGND VGND VPWR VPWR sky130_fd_sc_hd__decap_3
X_0677_ _0195_ _0202_ VGND VGND VPWR VPWR net80 sky130_fd_sc_hd__or2_1
XFILLER_29_228 VGND VGND VPWR VPWR sky130_fd_sc_hd__fill_2
XFILLER_44_209 VPWR VGND VPWR VGND sky130_ef_sc_hd__decap_12
XFILLER_20_172 VGND VGND VPWR VPWR sky130_fd_sc_hd__decap_3
XFILLER_20_194 VGND VGND VPWR VPWR sky130_fd_sc_hd__fill_2
XTAP_TAPCELL_ROW_7_143 VGND VPWR sky130_fd_sc_hd__tapvpwrvgnd_1
XFILLER_28_250 VGND VGND VPWR VPWR sky130_fd_sc_hd__fill_2
X_0531_ ten_s\[3\] VGND VGND VPWR VPWR _0086_ sky130_fd_sc_hd__inv_2
XFILLER_7_110 VGND VGND VPWR VPWR sky130_fd_sc_hd__fill_2
X_0600_ _0140_ _0141_ net104 VGND VGND VPWR VPWR net88 sky130_fd_sc_hd__or3_1
XFILLER_14_3 VGND VGND VPWR VPWR sky130_fd_sc_hd__decap_8
XFILLER_34_253 VPWR VGND VPWR VGND sky130_ef_sc_hd__decap_12
X_1014_ _0437_ _0438_ VGND VGND VPWR VPWR _0439_ sky130_fd_sc_hd__nor2_1
XFILLER_26_209 VGND VGND VPWR VPWR sky130_fd_sc_hd__decap_8
XFILLER_8_81 VGND VGND VPWR VPWR sky130_fd_sc_hd__decap_3
X_0729_ net122 _0244_ top_counter.day_counter.unit_d\[3\] VGND VGND VPWR VPWR _0245_
+ sky130_fd_sc_hd__a21oi_1
XFILLER_27_57 VPWR VGND VPWR VGND sky130_ef_sc_hd__decap_12
XTAP_TAPCELL_ROW_35_281 VGND VPWR sky130_fd_sc_hd__tapvpwrvgnd_1
XFILLER_40_289 VGND VGND VPWR VPWR sky130_fd_sc_hd__decap_3
XFILLER_4_124 VPWR VGND VPWR VGND sky130_ef_sc_hd__decap_12
XTAP_TAPCELL_ROW_10_159 VGND VPWR sky130_fd_sc_hd__tapvpwrvgnd_1
XTAP_TAPCELL_ROW_49_351 VGND VPWR sky130_fd_sc_hd__tapvpwrvgnd_1
Xtop_century_clock_146 VGND VGND VPWR VPWR top_century_clock_146/HI led_thou_y[0]
+ sky130_fd_sc_hd__conb_1
XFILLER_13_15 VGND VGND VPWR VPWR sky130_fd_sc_hd__fill_1
XTAP_TAPCELL_ROW_24_229 VGND VPWR sky130_fd_sc_hd__tapvpwrvgnd_1
XFILLER_22_289 VGND VGND VPWR VPWR sky130_fd_sc_hd__decap_3
XFILLER_38_45 VPWR VGND VPWR VGND sky130_ef_sc_hd__decap_12
XPHY_EDGE_ROW_35_Left_85 VGND VGND VPWR VPWR sky130_fd_sc_hd__decap_3
XFILLER_13_201 VGND VGND VPWR VPWR sky130_fd_sc_hd__fill_1
XFILLER_48_153 VGND VGND VPWR VPWR sky130_fd_sc_hd__decap_6
XFILLER_0_182 VGND VGND VPWR VPWR sky130_fd_sc_hd__decap_3
XFILLER_48_197 VPWR VGND VPWR VGND sky130_ef_sc_hd__decap_12
X_0994_ top_counter.day_in_month_decode.unit_mo\[2\] top_counter.day_in_month_decode.unit_mo\[3\]
+ VGND VGND VPWR VPWR _0428_ sky130_fd_sc_hd__xnor2_1
XFILLER_5_93 VGND VGND VPWR VPWR sky130_fd_sc_hd__fill_1
XFILLER_39_142 VGND VGND VPWR VPWR sky130_fd_sc_hd__decap_8
XFILLER_49_77 VGND VGND VPWR VPWR sky130_fd_sc_hd__decap_3
XFILLER_45_134 VGND VGND VPWR VPWR sky130_fd_sc_hd__decap_4
XTAP_TAPCELL_ROW_43_324 VGND VPWR sky130_fd_sc_hd__tapvpwrvgnd_1
X_1193_ clknet_3_1__leaf_clk _0054_ net138 VGND VGND VPWR VPWR min_counter_alarm.unit_m_alarm\[2\]
+ sky130_fd_sc_hd__dfrtp_1
XFILLER_36_189 VGND VGND VPWR VPWR sky130_fd_sc_hd__decap_6
X_0977_ net130 _0418_ _0413_ VGND VGND VPWR VPWR _0011_ sky130_fd_sc_hd__mux2_1
XFILLER_10_27 VGND VGND VPWR VPWR sky130_fd_sc_hd__fill_1
XFILLER_27_167 VGND VGND VPWR VPWR sky130_fd_sc_hd__fill_1
XTAP_TAPCELL_ROW_40_305 VGND VPWR sky130_fd_sc_hd__tapvpwrvgnd_1
XPHY_EDGE_ROW_14_Right_14 VGND VGND VPWR VPWR sky130_fd_sc_hd__decap_3
Xclkbuf_3_3__f_clk clknet_0_clk VGND VGND VPWR VPWR clknet_3_3__leaf_clk sky130_fd_sc_hd__clkbuf_16
XFILLER_2_277 VPWR VGND VPWR VGND sky130_ef_sc_hd__decap_12
XPHY_EDGE_ROW_23_Right_23 VGND VGND VPWR VPWR sky130_fd_sc_hd__decap_3
XFILLER_18_134 VGND VGND VPWR VPWR sky130_fd_sc_hd__decap_6
XFILLER_33_137 VPWR VGND VPWR VGND sky130_ef_sc_hd__decap_12
XPHY_EDGE_ROW_32_Right_32 VGND VGND VPWR VPWR sky130_fd_sc_hd__decap_3
X_0900_ _0190_ _0357_ VGND VGND VPWR VPWR _0359_ sky130_fd_sc_hd__nand2_1
X_0831_ net131 _0307_ _0310_ _0312_ VGND VGND VPWR VPWR net54 sky130_fd_sc_hd__a22oi_1
X_0693_ _0215_ _0218_ VGND VGND VPWR VPWR _0219_ sky130_fd_sc_hd__nand2_1
X_0762_ _0252_ _0268_ _0269_ _0270_ VGND VGND VPWR VPWR net28 sky130_fd_sc_hd__a31o_1
XFILLER_44_3 VPWR VGND VPWR VGND sky130_ef_sc_hd__decap_12
XPHY_EDGE_ROW_41_Right_41 VGND VGND VPWR VPWR sky130_fd_sc_hd__decap_3
XPHY_EDGE_ROW_22_Left_72 VGND VGND VPWR VPWR sky130_fd_sc_hd__decap_3
XFILLER_49_281 VPWR VGND VPWR VGND sky130_ef_sc_hd__decap_12
XFILLER_49_270 VGND VGND VPWR VPWR sky130_fd_sc_hd__decap_8
X_1176_ clknet_3_2__leaf_clk top_counter.min_counter.d_u1 net139 VGND VGND VPWR VPWR
+ top_counter.min_counter.u1 sky130_fd_sc_hd__dfrtp_4
XFILLER_16_7 VGND VGND VPWR VPWR sky130_fd_sc_hd__decap_3
X_1030_ net1 control_unit.select_time\[2\] _0369_ VGND VGND VPWR VPWR _0451_ sky130_fd_sc_hd__a21o_1
X_0814_ _0095_ hun_y\[1\] VGND VGND VPWR VPWR _0301_ sky130_fd_sc_hd__or2_1
XTAP_TAPCELL_ROW_16_187 VGND VPWR sky130_fd_sc_hd__tapvpwrvgnd_1
X_0676_ top_counter.min_counter.u2 _0191_ _0198_ _0195_ VGND VGND VPWR VPWR net79
+ sky130_fd_sc_hd__a31o_1
X_0745_ ten_h\[2\] _0249_ VGND VGND VPWR VPWR _0257_ sky130_fd_sc_hd__and2_1
X_1159_ clknet_3_7__leaf_clk _0027_ net142 VGND VGND VPWR VPWR top_counter.day_counter.unit_d\[3\]
+ sky130_fd_sc_hd__dfrtp_1
XTAP_TAPCELL_ROW_7_144 VGND VPWR sky130_fd_sc_hd__tapvpwrvgnd_1
XFILLER_43_221 VGND VGND VPWR VPWR sky130_fd_sc_hd__decap_3
X_0530_ net114 VGND VGND VPWR VPWR _0085_ sky130_fd_sc_hd__inv_2
XFILLER_34_265 VPWR VGND VPWR VGND sky130_ef_sc_hd__decap_12
XFILLER_34_221 VPWR VGND VPWR VGND sky130_ef_sc_hd__decap_12
X_1013_ control_unit.mode_alarm\[0\] control_unit.mode_alarm\[1\] net1 VGND VGND VPWR
+ VPWR _0438_ sky130_fd_sc_hd__nand3b_2
X_0728_ net121 net120 VGND VGND VPWR VPWR _0244_ sky130_fd_sc_hd__nor2_1
XPHY_EDGE_ROW_4_Right_4 VGND VGND VPWR VPWR sky130_fd_sc_hd__decap_3
X_0659_ top_counter.min_counter.u1 top_counter.min_counter.u2 VGND VGND VPWR VPWR
+ _0192_ sky130_fd_sc_hd__nor2_1
XTAP_TAPCELL_ROW_4_125 VGND VPWR sky130_fd_sc_hd__tapvpwrvgnd_1
XFILLER_27_69 VPWR VGND VPWR VGND sky130_ef_sc_hd__decap_12
XFILLER_43_57 VGND VGND VPWR VPWR sky130_fd_sc_hd__decap_3
XTAP_TAPCELL_ROW_35_282 VGND VPWR sky130_fd_sc_hd__tapvpwrvgnd_1
XFILLER_4_136 VGND VGND VPWR VPWR sky130_fd_sc_hd__decap_4
XFILLER_4_29 VGND VGND VPWR VPWR sky130_fd_sc_hd__decap_8
XFILLER_16_243 VGND VGND VPWR VPWR sky130_fd_sc_hd__decap_8
XFILLER_16_276 VPWR VGND VPWR VGND sky130_ef_sc_hd__decap_12
XFILLER_31_279 VGND VGND VPWR VPWR sky130_fd_sc_hd__fill_1
XFILLER_3_191 VGND VGND VPWR VPWR sky130_fd_sc_hd__decap_6
XFILLER_3_180 VGND VGND VPWR VPWR sky130_fd_sc_hd__fill_1
XTAP_TAPCELL_ROW_49_352 VGND VPWR sky130_fd_sc_hd__tapvpwrvgnd_1
Xtop_century_clock_147 VGND VGND VPWR VPWR top_century_clock_147/HI led_thou_y[2]
+ sky130_fd_sc_hd__conb_1
XFILLER_38_57 VPWR VGND VPWR VGND sky130_ef_sc_hd__decap_12
XFILLER_0_161 VGND VGND VPWR VPWR sky130_fd_sc_hd__decap_3
X_0993_ net157 _0427_ VGND VGND VPWR VPWR _0018_ sky130_fd_sc_hd__xnor2_1
XFILLER_8_250 VGND VGND VPWR VPWR sky130_fd_sc_hd__fill_2
X_1192_ clknet_3_0__leaf_clk _0053_ net138 VGND VGND VPWR VPWR min_counter_alarm.unit_m_alarm\[1\]
+ sky130_fd_sc_hd__dfrtp_1
X_0976_ _0404_ _0417_ VGND VGND VPWR VPWR _0418_ sky130_fd_sc_hd__nor2_1
XFILLER_27_113 VPWR VGND VPWR VGND sky130_ef_sc_hd__decap_12
XFILLER_42_138 VGND VGND VPWR VPWR sky130_fd_sc_hd__fill_2
XFILLER_42_105 VGND VGND VPWR VPWR sky130_fd_sc_hd__fill_1
XTAP_TAPCELL_ROW_40_306 VGND VPWR sky130_fd_sc_hd__tapvpwrvgnd_1
XFILLER_4_3 VPWR VGND VPWR VGND sky130_ef_sc_hd__decap_12
XFILLER_2_289 VGND VGND VPWR VPWR sky130_fd_sc_hd__decap_4
XFILLER_18_113 VPWR VGND VPWR VGND sky130_ef_sc_hd__decap_12
X_0830_ net130 _0311_ VGND VGND VPWR VPWR _0312_ sky130_fd_sc_hd__or2_1
XFILLER_33_149 VPWR VGND VPWR VGND sky130_ef_sc_hd__decap_12
X_0761_ _0255_ _0260_ _0252_ VGND VGND VPWR VPWR _0270_ sky130_fd_sc_hd__a21oi_1
X_0692_ hour_counter_alarm.unit_h_alarm\[3\] net108 _0217_ VGND VGND VPWR VPWR _0218_
+ sky130_fd_sc_hd__a21oi_2
XFILLER_49_293 VGND VGND VPWR VPWR sky130_fd_sc_hd__decap_3
X_1175_ clknet_3_0__leaf_clk top_counter.min_counter.d_u2 net136 VGND VGND VPWR VPWR
+ top_counter.min_counter.u2 sky130_fd_sc_hd__dfrtp_1
X_0959_ _0404_ _0406_ VGND VGND VPWR VPWR _0408_ sky130_fd_sc_hd__or2_1
XFILLER_11_82 VPWR VGND VPWR VGND sky130_ef_sc_hd__decap_12
XFILLER_21_108 VGND VGND VPWR VPWR sky130_fd_sc_hd__decap_4
X_0813_ hun_y\[2\] _0297_ _0300_ hun_y\[0\] VGND VGND VPWR VPWR net13 sky130_fd_sc_hd__a22o_1
XTAP_TAPCELL_ROW_16_188 VGND VPWR sky130_fd_sc_hd__tapvpwrvgnd_1
X_0675_ net116 _0082_ _0190_ _0203_ VGND VGND VPWR VPWR net78 sky130_fd_sc_hd__o31a_1
X_0744_ _0072_ _0255_ _0252_ VGND VGND VPWR VPWR _0256_ sky130_fd_sc_hd__o21ai_1
X_1158_ clknet_3_5__leaf_clk _0026_ net145 VGND VGND VPWR VPWR top_counter.day_counter.unit_d\[2\]
+ sky130_fd_sc_hd__dfrtp_1
X_1089_ hour_counter_alarm.ten_h_alarm\[3\] _0489_ _0490_ VGND VGND VPWR VPWR _0051_
+ sky130_fd_sc_hd__o21ba_1
XFILLER_16_27 VGND VGND VPWR VPWR sky130_fd_sc_hd__fill_1
XFILLER_43_277 VGND VGND VPWR VPWR sky130_fd_sc_hd__decap_3
XFILLER_43_233 VPWR VGND VPWR VGND sky130_ef_sc_hd__decap_12
XFILLER_43_288 VGND VGND VPWR VPWR sky130_fd_sc_hd__decap_8
XFILLER_7_178 VPWR VGND VPWR VGND sky130_ef_sc_hd__decap_12
X_1012_ min_counter_alarm.unit_m_alarm\[1\] min_counter_alarm.unit_m_alarm\[2\] min_counter_alarm.unit_m_alarm\[3\]
+ min_counter_alarm.unit_m_alarm\[0\] VGND VGND VPWR VPWR _0437_ sky130_fd_sc_hd__or4bb_1
XFILLER_19_274 VGND VGND VPWR VPWR sky130_fd_sc_hd__fill_1
XFILLER_34_277 VPWR VGND VPWR VGND sky130_ef_sc_hd__decap_12
XFILLER_34_233 VPWR VGND VPWR VGND sky130_ef_sc_hd__decap_12
X_0727_ _0235_ _0242_ net120 VGND VGND VPWR VPWR _0243_ sky130_fd_sc_hd__or3b_1
XTAP_TAPCELL_ROW_4_126 VGND VPWR sky130_fd_sc_hd__tapvpwrvgnd_1
X_0658_ top_counter.min_counter.c0 top_counter.min_counter.u1 VGND VGND VPWR VPWR
+ _0191_ sky130_fd_sc_hd__nand2_1
X_0589_ _0122_ _0123_ _0124_ _0142_ VGND VGND VPWR VPWR _0143_ sky130_fd_sc_hd__or4_1
XFILLER_25_211 VGND VGND VPWR VPWR sky130_fd_sc_hd__decap_8
XTAP_TAPCELL_ROW_35_283 VGND VPWR sky130_fd_sc_hd__tapvpwrvgnd_1
XFILLER_31_225 VPWR VGND VPWR VGND sky130_ef_sc_hd__decap_12
XFILLER_16_288 VGND VGND VPWR VPWR sky130_fd_sc_hd__decap_4
XFILLER_17_81 VGND VGND VPWR VPWR sky130_fd_sc_hd__decap_4
Xtop_century_clock_148 VGND VGND VPWR VPWR top_century_clock_148/HI led_thou_y[3]
+ sky130_fd_sc_hd__conb_1
XTAP_TAPCELL_ROW_49_353 VGND VPWR sky130_fd_sc_hd__tapvpwrvgnd_1
XFILLER_13_28 VPWR VGND VPWR VGND sky130_ef_sc_hd__decap_12
XFILLER_1_118 VPWR VGND VPWR VGND sky130_ef_sc_hd__decap_12
XFILLER_38_69 VGND VGND VPWR VPWR sky130_fd_sc_hd__decap_8
XFILLER_13_225 VPWR VGND VPWR VGND sky130_ef_sc_hd__decap_12
XTAP_TAPCELL_ROW_23_220 VGND VPWR sky130_fd_sc_hd__tapvpwrvgnd_1
XFILLER_48_100 VGND VGND VPWR VPWR sky130_fd_sc_hd__decap_6
XFILLER_0_195 VGND VGND VPWR VPWR sky130_fd_sc_hd__fill_1
X_0992_ _0424_ _0426_ _0427_ VGND VGND VPWR VPWR _0017_ sky130_fd_sc_hd__and3_1
XFILLER_5_51 VGND VGND VPWR VPWR sky130_fd_sc_hd__decap_4
XFILLER_8_295 VGND VGND VPWR VPWR sky130_fd_sc_hd__fill_1
XFILLER_39_177 VGND VGND VPWR VPWR sky130_fd_sc_hd__decap_3
XFILLER_39_111 VGND VGND VPWR VPWR sky130_fd_sc_hd__fill_1
XFILLER_24_16 VPWR VGND VPWR VGND sky130_ef_sc_hd__decap_12
XFILLER_49_57 VGND VGND VPWR VPWR sky130_fd_sc_hd__fill_2
XFILLER_30_92 VPWR VGND VPWR VGND sky130_ef_sc_hd__decap_12
XFILLER_39_7 VGND VGND VPWR VPWR sky130_fd_sc_hd__decap_4
X_1191_ clknet_3_2__leaf_clk _0052_ net138 VGND VGND VPWR VPWR min_counter_alarm.unit_m_alarm\[0\]
+ sky130_fd_sc_hd__dfrtp_1
X_0975_ net130 _0317_ VGND VGND VPWR VPWR _0417_ sky130_fd_sc_hd__xnor2_1
XFILLER_10_29 VPWR VGND VPWR VGND sky130_ef_sc_hd__decap_12
XFILLER_27_125 VPWR VGND VPWR VGND sky130_ef_sc_hd__decap_12
XFILLER_42_117 VGND VGND VPWR VPWR sky130_fd_sc_hd__fill_1
XTAP_TAPCELL_ROW_40_307 VGND VPWR sky130_fd_sc_hd__tapvpwrvgnd_1
XFILLER_35_48 VGND VGND VPWR VPWR sky130_fd_sc_hd__fill_1
XFILLER_35_37 VGND VGND VPWR VPWR sky130_fd_sc_hd__decap_3
XFILLER_27_169 VPWR VGND VPWR VGND sky130_ef_sc_hd__decap_12
XFILLER_18_125 VGND VGND VPWR VPWR sky130_fd_sc_hd__decap_6
X_0760_ _0260_ _0266_ VGND VGND VPWR VPWR _0269_ sky130_fd_sc_hd__nand2_1
X_0691_ net105 _0216_ top_counter.hour_counter.unit_h\[3\] VGND VGND VPWR VPWR _0217_
+ sky130_fd_sc_hd__and3b_1
X_1174_ clknet_3_0__leaf_clk top_counter.min_counter.d_t2 net136 VGND VGND VPWR VPWR
+ top_counter.min_counter.t2 sky130_fd_sc_hd__dfrtp_4
XFILLER_24_128 VPWR VGND VPWR VGND sky130_ef_sc_hd__decap_12
X_0958_ _0406_ VGND VGND VPWR VPWR _0407_ sky130_fd_sc_hd__inv_2
X_0889_ control_unit.current_state\[0\] net2 _0350_ VGND VGND VPWR VPWR control_unit.next_state\[0\]
+ sky130_fd_sc_hd__o21a_1
XFILLER_46_58 VGND VGND VPWR VPWR sky130_fd_sc_hd__decap_8
XFILLER_11_72 VGND VGND VPWR VPWR sky130_fd_sc_hd__decap_6
XFILLER_11_94 VPWR VGND VPWR VGND sky130_ef_sc_hd__decap_12
XFILLER_46_253 VPWR VGND VPWR VGND sky130_ef_sc_hd__decap_12
XFILLER_36_80 VGND VGND VPWR VPWR sky130_fd_sc_hd__decap_4
XTAP_TAPCELL_ROW_16_189 VGND VPWR sky130_fd_sc_hd__tapvpwrvgnd_1
X_0812_ hun_y\[1\] hun_y\[3\] VGND VGND VPWR VPWR _0300_ sky130_fd_sc_hd__nand2_1
X_0743_ _0253_ _0254_ VGND VGND VPWR VPWR _0255_ sky130_fd_sc_hd__and2_1
X_0674_ _0079_ top_counter.min_counter.u1 _0081_ top_counter.min_counter.u3 VGND VGND
+ VPWR VPWR _0203_ sky130_fd_sc_hd__a31o_1
X_1157_ clknet_3_5__leaf_clk _0025_ net141 VGND VGND VPWR VPWR top_counter.day_counter.unit_d\[1\]
+ sky130_fd_sc_hd__dfrtp_1
XFILLER_32_27 VGND VGND VPWR VPWR sky130_fd_sc_hd__fill_1
X_1088_ hour_counter_alarm.ten_h_alarm\[1\] hour_counter_alarm.ten_h_alarm\[2\] hour_counter_alarm.ten_h_alarm\[3\]
+ _0485_ net5 VGND VGND VPWR VPWR _0490_ sky130_fd_sc_hd__a41o_1
XFILLER_20_186 VGND VGND VPWR VPWR sky130_fd_sc_hd__decap_8
XFILLER_20_197 VPWR VGND VPWR VGND sky130_ef_sc_hd__decap_12
XFILLER_43_245 VPWR VGND VPWR VGND sky130_ef_sc_hd__decap_12
XFILLER_43_201 VPWR VGND VPWR VGND sky130_ef_sc_hd__decap_12
XFILLER_28_253 VPWR VGND VPWR VGND sky130_ef_sc_hd__decap_12
XFILLER_7_113 VGND VGND VPWR VPWR sky130_fd_sc_hd__decap_4
X_1011_ _0394_ _0436_ VGND VGND VPWR VPWR _0027_ sky130_fd_sc_hd__and2_1
XFILLER_21_7 VPWR VGND VPWR VGND sky130_ef_sc_hd__decap_12
XFILLER_34_289 VGND VGND VPWR VPWR sky130_fd_sc_hd__decap_3
XFILLER_34_245 VGND VGND VPWR VPWR sky130_fd_sc_hd__decap_6
X_0726_ top_counter.day_counter.unit_d\[1\] net122 VGND VGND VPWR VPWR _0242_ sky130_fd_sc_hd__and2b_1
X_0588_ net115 min_counter_alarm.ten_m_alarm\[1\] VGND VGND VPWR VPWR _0142_ sky130_fd_sc_hd__and2b_1
XTAP_TAPCELL_ROW_4_127 VGND VPWR sky130_fd_sc_hd__tapvpwrvgnd_1
X_0657_ _0079_ _0080_ VGND VGND VPWR VPWR _0190_ sky130_fd_sc_hd__nor2_2
XFILLER_43_15 VPWR VGND VPWR VGND sky130_ef_sc_hd__decap_12
X_1209_ clknet_3_1__leaf_clk control_unit.next_state\[0\] net138 VGND VGND VPWR VPWR
+ control_unit.current_state\[0\] sky130_fd_sc_hd__dfrtp_2
XFILLER_25_223 VGND VGND VPWR VPWR sky130_fd_sc_hd__fill_1
XFILLER_25_289 VGND VGND VPWR VPWR sky130_fd_sc_hd__decap_3
XTAP_TAPCELL_ROW_35_284 VGND VPWR sky130_fd_sc_hd__tapvpwrvgnd_1
XFILLER_16_223 VGND VGND VPWR VPWR sky130_fd_sc_hd__fill_1
XFILLER_31_237 VPWR VGND VPWR VGND sky130_ef_sc_hd__decap_12
XFILLER_12_3 VPWR VGND VPWR VGND sky130_ef_sc_hd__decap_12
XTAP_TAPCELL_ROW_49_354 VGND VPWR sky130_fd_sc_hd__tapvpwrvgnd_1
Xtop_century_clock_149 VGND VGND VPWR VPWR top_century_clock_149/HI led_thou_y[5]
+ sky130_fd_sc_hd__conb_1
XTAP_TAPCELL_ROW_32_265 VGND VPWR sky130_fd_sc_hd__tapvpwrvgnd_1
X_0709_ _0211_ _0222_ _0218_ VGND VGND VPWR VPWR _0232_ sky130_fd_sc_hd__o21ba_1
XFILLER_38_26 VGND VGND VPWR VPWR sky130_fd_sc_hd__fill_2
XFILLER_13_237 VGND VGND VPWR VPWR sky130_fd_sc_hd__decap_4
XTAP_TAPCELL_ROW_23_221 VGND VPWR sky130_fd_sc_hd__tapvpwrvgnd_1
XFILLER_48_134 VGND VGND VPWR VPWR sky130_fd_sc_hd__decap_6
XFILLER_48_123 VGND VGND VPWR VPWR sky130_fd_sc_hd__decap_4
XFILLER_0_141 VGND VGND VPWR VPWR sky130_fd_sc_hd__fill_2
XTAP_TAPCELL_ROW_46_335 VGND VPWR sky130_fd_sc_hd__tapvpwrvgnd_1
XFILLER_44_80 VGND VGND VPWR VPWR sky130_fd_sc_hd__decap_4
XFILLER_8_230 VPWR VGND VPWR VGND sky130_ef_sc_hd__decap_12
X_0991_ _0178_ _0423_ VGND VGND VPWR VPWR _0427_ sky130_fd_sc_hd__nand2_1
XFILLER_39_167 VGND VGND VPWR VPWR sky130_fd_sc_hd__fill_1
XFILLER_40_27 VGND VGND VPWR VPWR sky130_fd_sc_hd__fill_1
XPHY_EDGE_ROW_39_Left_89 VGND VGND VPWR VPWR sky130_fd_sc_hd__decap_3
XFILLER_5_277 VGND VGND VPWR VPWR sky130_fd_sc_hd__decap_3
XFILLER_5_211 VPWR VGND VPWR VGND sky130_ef_sc_hd__decap_12
XFILLER_39_91 VGND VGND VPWR VPWR sky130_fd_sc_hd__decap_3
XFILLER_36_104 VGND VGND VPWR VPWR sky130_fd_sc_hd__fill_1
X_1190_ clknet_3_2__leaf_clk _0051_ net139 VGND VGND VPWR VPWR hour_counter_alarm.ten_h_alarm\[3\]
+ sky130_fd_sc_hd__dfrtp_2
X_0974_ net155 _0416_ VGND VGND VPWR VPWR _0010_ sky130_fd_sc_hd__xor2_1
XFILLER_27_137 VPWR VGND VPWR VGND sky130_ef_sc_hd__decap_12
XTAP_TAPCELL_ROW_40_308 VGND VPWR sky130_fd_sc_hd__tapvpwrvgnd_1
XFILLER_35_181 VPWR VGND VPWR VGND sky130_ef_sc_hd__decap_12
X_0690_ net118 top_counter.hour_counter.unit_h\[2\] _0207_ VGND VGND VPWR VPWR _0216_
+ sky130_fd_sc_hd__or3_1
XFILLER_49_251 VGND VGND VPWR VPWR sky130_fd_sc_hd__fill_1
XFILLER_2_42 VGND VGND VPWR VPWR sky130_fd_sc_hd__fill_2
X_1173_ clknet_3_0__leaf_clk top_counter.min_counter.d_u3 net136 VGND VGND VPWR VPWR
+ top_counter.min_counter.u3 sky130_fd_sc_hd__dfrtp_4
XPHY_EDGE_ROW_10_Right_10 VGND VGND VPWR VPWR sky130_fd_sc_hd__decap_3
XFILLER_32_195 VGND VGND VPWR VPWR sky130_fd_sc_hd__fill_1
X_0957_ _0169_ _0175_ _0302_ _0405_ VGND VGND VPWR VPWR _0406_ sky130_fd_sc_hd__and4_2
X_0888_ control_unit.current_state\[0\] net2 control_unit.current_state\[1\] VGND
+ VGND VPWR VPWR _0350_ sky130_fd_sc_hd__a21oi_1
XFILLER_46_15 VPWR VGND VPWR VGND sky130_ef_sc_hd__decap_12
XFILLER_11_51 VGND VGND VPWR VPWR sky130_fd_sc_hd__decap_4
XFILLER_46_265 VPWR VGND VPWR VGND sky130_ef_sc_hd__decap_12
XFILLER_36_92 VPWR VGND VPWR VGND sky130_ef_sc_hd__decap_12
XFILLER_14_195 VGND VGND VPWR VPWR sky130_fd_sc_hd__fill_1
XPHY_EDGE_ROW_26_Left_76 VGND VGND VPWR VPWR sky130_fd_sc_hd__decap_3
X_0811_ hun_y\[2\] _0296_ _0299_ VGND VGND VPWR VPWR net12 sky130_fd_sc_hd__a21oi_1
X_0673_ net116 _0190_ _0193_ top_counter.min_counter.u3 _0202_ VGND VGND VPWR VPWR
+ net77 sky130_fd_sc_hd__a221o_1
X_0742_ net105 _0249_ VGND VGND VPWR VPWR _0254_ sky130_fd_sc_hd__or2_1
XFILLER_42_3 VPWR VGND VPWR VGND sky130_ef_sc_hd__decap_12
XFILLER_37_210 VPWR VGND VPWR VGND sky130_ef_sc_hd__decap_12
X_1156_ clknet_3_5__leaf_clk _0024_ net141 VGND VGND VPWR VPWR top_counter.day_counter.unit_d\[0\]
+ sky130_fd_sc_hd__dfstp_1
X_1087_ net107 _0488_ _0489_ VGND VGND VPWR VPWR _0050_ sky130_fd_sc_hd__nor3_1
XFILLER_16_29 VPWR VGND VPWR VGND sky130_ef_sc_hd__decap_12
XFILLER_28_265 VGND VGND VPWR VPWR sky130_fd_sc_hd__fill_2
XFILLER_43_257 VPWR VGND VPWR VGND sky130_ef_sc_hd__decap_12
XFILLER_43_213 VGND VGND VPWR VPWR sky130_fd_sc_hd__decap_8
XFILLER_7_169 VGND VGND VPWR VPWR sky130_fd_sc_hd__decap_3
XFILLER_11_165 VGND VGND VPWR VPWR sky130_fd_sc_hd__decap_3
XFILLER_22_83 VGND VGND VPWR VPWR sky130_fd_sc_hd__fill_1
XFILLER_47_91 VPWR VGND VPWR VGND sky130_ef_sc_hd__decap_12
X_1010_ net119 _0435_ VGND VGND VPWR VPWR _0436_ sky130_fd_sc_hd__xor2_1
XFILLER_19_221 VGND VGND VPWR VPWR sky130_fd_sc_hd__decap_3
XFILLER_42_290 VGND VGND VPWR VPWR sky130_fd_sc_hd__fill_2
XFILLER_8_52 VGND VGND VPWR VPWR sky130_fd_sc_hd__fill_1
X_0725_ net120 _0240_ _0241_ net122 VGND VGND VPWR VPWR net62 sky130_fd_sc_hd__a22o_1
XFILLER_8_96 VPWR VGND VPWR VGND sky130_ef_sc_hd__decap_12
X_0656_ net125 _0090_ _0181_ _0186_ VGND VGND VPWR VPWR net87 sky130_fd_sc_hd__a31o_1
XTAP_TAPCELL_ROW_4_128 VGND VPWR sky130_fd_sc_hd__tapvpwrvgnd_1
X_0587_ top_counter.second_counter.unit_s\[3\] _0137_ _0139_ VGND VGND VPWR VPWR _0141_
+ sky130_fd_sc_hd__a21oi_1
X_1208_ clknet_3_1__leaf_clk _0069_ net137 VGND VGND VPWR VPWR control_unit.mode_display\[1\]
+ sky130_fd_sc_hd__dfrtp_1
XFILLER_43_27 VPWR VGND VPWR VGND sky130_ef_sc_hd__decap_12
X_1139_ clknet_3_7__leaf_clk _0007_ net143 VGND VGND VPWR VPWR hun_y\[3\] sky130_fd_sc_hd__dfrtp_4
XFILLER_25_279 VGND VGND VPWR VPWR sky130_fd_sc_hd__fill_1
XFILLER_31_249 VPWR VGND VPWR VGND sky130_ef_sc_hd__decap_12
XFILLER_24_290 VGND VGND VPWR VPWR sky130_fd_sc_hd__fill_2
XFILLER_3_172 VGND VGND VPWR VPWR sky130_fd_sc_hd__decap_8
XTAP_TAPCELL_ROW_49_355 VGND VPWR sky130_fd_sc_hd__tapvpwrvgnd_1
Xhold1 ten_y\[2\] VGND VGND VPWR VPWR net155 sky130_fd_sc_hd__dlygate4sd3_1
XPHY_EDGE_ROW_8_Right_8 VGND VGND VPWR VPWR sky130_fd_sc_hd__decap_3
XTAP_TAPCELL_ROW_32_266 VGND VPWR sky130_fd_sc_hd__tapvpwrvgnd_1
XPHY_EDGE_ROW_39_Right_39 VGND VGND VPWR VPWR sky130_fd_sc_hd__decap_3
XPHY_EDGE_ROW_13_Left_63 VGND VGND VPWR VPWR sky130_fd_sc_hd__decap_3
X_0708_ _0222_ _0228_ _0218_ VGND VGND VPWR VPWR _0231_ sky130_fd_sc_hd__o21ai_1
X_0639_ net124 _0178_ VGND VGND VPWR VPWR _0179_ sky130_fd_sc_hd__or2_1
XPHY_EDGE_ROW_48_Right_48 VGND VGND VPWR VPWR sky130_fd_sc_hd__decap_3
XFILLER_21_260 VGND VGND VPWR VPWR sky130_fd_sc_hd__decap_8
XTAP_TAPCELL_ROW_23_222 VGND VPWR sky130_fd_sc_hd__tapvpwrvgnd_1
XFILLER_0_175 VGND VGND VPWR VPWR sky130_fd_sc_hd__decap_3
XFILLER_0_197 VGND VGND VPWR VPWR sky130_fd_sc_hd__fill_2
XTAP_TAPCELL_ROW_46_336 VGND VPWR sky130_fd_sc_hd__tapvpwrvgnd_1
XFILLER_28_93 VPWR VGND VPWR VGND sky130_ef_sc_hd__decap_12
X_0990_ _0423_ _0425_ VGND VGND VPWR VPWR _0426_ sky130_fd_sc_hd__nand2_1
XFILLER_8_242 VGND VGND VPWR VPWR sky130_fd_sc_hd__decap_8
XFILLER_8_253 VPWR VGND VPWR VGND sky130_ef_sc_hd__decap_12
XFILLER_12_260 VGND VGND VPWR VPWR sky130_fd_sc_hd__decap_6
XFILLER_5_97 VGND VGND VPWR VPWR sky130_fd_sc_hd__decap_3
XFILLER_47_190 VPWR VGND VPWR VGND sky130_ef_sc_hd__decap_12
XFILLER_10_219 VGND VGND VPWR VPWR sky130_fd_sc_hd__fill_2
XFILLER_24_29 VPWR VGND VPWR VGND sky130_ef_sc_hd__decap_12
XFILLER_49_15 VPWR VGND VPWR VGND sky130_ef_sc_hd__decap_12
XFILLER_45_138 VGND VGND VPWR VPWR sky130_fd_sc_hd__fill_1
XFILLER_45_105 VGND VGND VPWR VPWR sky130_fd_sc_hd__decap_4
XFILLER_5_256 VGND VGND VPWR VPWR sky130_fd_sc_hd__decap_6
XFILLER_5_223 VGND VGND VPWR VPWR sky130_fd_sc_hd__fill_1
XFILLER_30_50 VGND VGND VPWR VPWR sky130_fd_sc_hd__fill_1
XFILLER_30_83 VGND VGND VPWR VPWR sky130_fd_sc_hd__fill_1
X_0973_ _0403_ _0406_ _0306_ net102 VGND VGND VPWR VPWR _0416_ sky130_fd_sc_hd__o211a_1
XFILLER_35_17 VGND VGND VPWR VPWR sky130_fd_sc_hd__fill_1
XFILLER_27_105 VGND VGND VPWR VPWR sky130_fd_sc_hd__decap_6
XFILLER_27_149 VPWR VGND VPWR VGND sky130_ef_sc_hd__decap_12
XTAP_TAPCELL_ROW_40_309 VGND VPWR sky130_fd_sc_hd__tapvpwrvgnd_1
XFILLER_35_193 VPWR VGND VPWR VGND sky130_ef_sc_hd__decap_12
XFILLER_49_230 VGND VGND VPWR VPWR sky130_fd_sc_hd__decap_4
XFILLER_1_281 VPWR VGND VPWR VGND sky130_ef_sc_hd__decap_12
X_1172_ clknet_3_0__leaf_clk top_counter.min_counter.d_t0 net136 VGND VGND VPWR VPWR
+ top_counter.min_counter.ct0 sky130_fd_sc_hd__dfrtp_1
X_0956_ _0311_ _0316_ VGND VGND VPWR VPWR _0405_ sky130_fd_sc_hd__and2_1
XFILLER_32_141 VPWR VGND VPWR VGND sky130_ef_sc_hd__decap_12
XFILLER_21_19 VPWR VGND VPWR VGND sky130_ef_sc_hd__decap_12
Xoutput100 net100 VGND VGND VPWR VPWR led_unit_y[5] sky130_fd_sc_hd__buf_2
X_0887_ net132 net133 _0349_ VGND VGND VPWR VPWR net24 sky130_fd_sc_hd__a21o_1
XFILLER_46_49 VGND VGND VPWR VPWR sky130_fd_sc_hd__decap_4
XFILLER_46_27 VGND VGND VPWR VPWR sky130_fd_sc_hd__fill_1
XFILLER_2_3 VPWR VGND VPWR VGND sky130_ef_sc_hd__decap_12
XFILLER_46_277 VPWR VGND VPWR VGND sky130_ef_sc_hd__decap_12
XFILLER_46_244 VGND VGND VPWR VPWR sky130_fd_sc_hd__decap_8
XPHY_EDGE_ROW_1_Left_51 VGND VGND VPWR VPWR sky130_fd_sc_hd__decap_3
X_0810_ hun_y\[3\] hun_y\[2\] _0298_ VGND VGND VPWR VPWR _0299_ sky130_fd_sc_hd__a21oi_1
XFILLER_14_141 VPWR VGND VPWR VGND sky130_ef_sc_hd__decap_12
X_0672_ _0082_ _0201_ VGND VGND VPWR VPWR _0202_ sky130_fd_sc_hd__and2_1
X_0741_ net105 _0206_ ten_h\[1\] VGND VGND VPWR VPWR _0253_ sky130_fd_sc_hd__o21ai_1
XFILLER_37_222 VGND VGND VPWR VPWR sky130_fd_sc_hd__fill_2
X_1155_ clknet_3_5__leaf_clk _0023_ net141 VGND VGND VPWR VPWR ten_mo\[3\] sky130_fd_sc_hd__dfrtp_4
X_1086_ hour_counter_alarm.ten_h_alarm\[1\] hour_counter_alarm.ten_h_alarm\[2\] _0485_
+ VGND VGND VPWR VPWR _0489_ sky130_fd_sc_hd__and3_1
XFILLER_16_19 VGND VGND VPWR VPWR sky130_fd_sc_hd__decap_8
X_0939_ ten_d\[1\] _0383_ _0390_ _0391_ VGND VGND VPWR VPWR _0392_ sky130_fd_sc_hd__a2bb2oi_1
XFILLER_32_29 VPWR VGND VPWR VGND sky130_ef_sc_hd__decap_12
XTAP_TAPCELL_ROW_15_180 VGND VPWR sky130_fd_sc_hd__tapvpwrvgnd_1
XPHY_EDGE_ROW_43_Left_93 VGND VGND VPWR VPWR sky130_fd_sc_hd__decap_3
XFILLER_43_269 VGND VGND VPWR VPWR sky130_fd_sc_hd__decap_8
XTAP_TAPCELL_ROW_29_250 VGND VPWR sky130_fd_sc_hd__tapvpwrvgnd_1
X_0724_ top_counter.day_counter.unit_d\[1\] net119 VGND VGND VPWR VPWR _0241_ sky130_fd_sc_hd__nand2_1
X_0586_ top_counter.second_counter.unit_s\[3\] _0137_ _0139_ VGND VGND VPWR VPWR _0140_
+ sky130_fd_sc_hd__and3_1
X_0655_ net124 _0187_ net125 VGND VGND VPWR VPWR net86 sky130_fd_sc_hd__o21a_1
XTAP_TAPCELL_ROW_4_129 VGND VPWR sky130_fd_sc_hd__tapvpwrvgnd_1
X_1207_ clknet_3_1__leaf_clk _0068_ net137 VGND VGND VPWR VPWR control_unit.mode_display\[0\]
+ sky130_fd_sc_hd__dfrtp_1
XFILLER_27_18 VPWR VGND VPWR VGND sky130_ef_sc_hd__decap_12
XFILLER_43_39 VPWR VGND VPWR VGND sky130_ef_sc_hd__decap_12
XFILLER_40_239 VGND VGND VPWR VPWR sky130_fd_sc_hd__decap_4
XFILLER_40_228 VGND VGND VPWR VPWR sky130_fd_sc_hd__decap_3
X_1138_ clknet_3_7__leaf_clk _0006_ net143 VGND VGND VPWR VPWR hun_y\[2\] sky130_fd_sc_hd__dfrtp_4
X_1069_ _0473_ _0474_ _0475_ VGND VGND VPWR VPWR _0046_ sky130_fd_sc_hd__and3b_1
XFILLER_16_258 VGND VGND VPWR VPWR sky130_fd_sc_hd__decap_6
XFILLER_17_51 VGND VGND VPWR VPWR sky130_fd_sc_hd__decap_4
XTAP_TAPCELL_ROW_49_356 VGND VPWR sky130_fd_sc_hd__tapvpwrvgnd_1
Xhold2 ten_s\[1\] VGND VGND VPWR VPWR net156 sky130_fd_sc_hd__dlygate4sd3_1
XTAP_TAPCELL_ROW_32_267 VGND VPWR sky130_fd_sc_hd__tapvpwrvgnd_1
Xmax_cap110 net111 VGND VGND VPWR VPWR net110 sky130_fd_sc_hd__buf_1
X_0707_ _0215_ _0222_ _0226_ VGND VGND VPWR VPWR _0230_ sky130_fd_sc_hd__and3_1
X_0569_ hour_counter_alarm.ten_h_alarm\[0\] ten_h\[0\] VGND VGND VPWR VPWR _0124_
+ sky130_fd_sc_hd__and2b_1
X_0638_ net127 net126 VGND VGND VPWR VPWR _0178_ sky130_fd_sc_hd__and2_1
XTAP_TAPCELL_ROW_23_223 VGND VPWR sky130_fd_sc_hd__tapvpwrvgnd_1
XFILLER_48_169 VPWR VGND VPWR VGND sky130_ef_sc_hd__decap_12
XFILLER_0_154 VGND VGND VPWR VPWR sky130_fd_sc_hd__decap_3
XFILLER_28_83 VGND VGND VPWR VPWR sky130_fd_sc_hd__fill_1
XTAP_TAPCELL_ROW_46_337 VGND VPWR sky130_fd_sc_hd__tapvpwrvgnd_1
XFILLER_8_265 VPWR VGND VPWR VGND sky130_ef_sc_hd__decap_12
XFILLER_12_294 VGND VGND VPWR VPWR sky130_fd_sc_hd__fill_2
XPHY_EDGE_ROW_30_Left_80 VGND VGND VPWR VPWR sky130_fd_sc_hd__decap_3
XFILLER_39_169 VGND VGND VPWR VPWR sky130_fd_sc_hd__decap_8
XFILLER_49_27 VGND VGND VPWR VPWR sky130_fd_sc_hd__fill_1
XFILLER_40_29 VGND VGND VPWR VPWR sky130_fd_sc_hd__decap_4
XFILLER_49_49 VGND VGND VPWR VPWR sky130_fd_sc_hd__decap_3
XFILLER_14_85 VGND VGND VPWR VPWR sky130_fd_sc_hd__decap_6
XFILLER_44_183 VPWR VGND VPWR VGND sky130_ef_sc_hd__decap_12
XFILLER_44_161 VGND VGND VPWR VPWR sky130_fd_sc_hd__fill_1
X_0972_ ten_y\[1\] _0415_ _0413_ VGND VGND VPWR VPWR _0009_ sky130_fd_sc_hd__mux2_1
XFILLER_35_161 VGND VGND VPWR VPWR sky130_fd_sc_hd__decap_6
XFILLER_35_29 VGND VGND VPWR VPWR sky130_fd_sc_hd__decap_8
XFILLER_41_175 VPWR VGND VPWR VGND sky130_ef_sc_hd__decap_12
XFILLER_41_61 VGND VGND VPWR VPWR sky130_fd_sc_hd__fill_1
XFILLER_41_50 VGND VGND VPWR VPWR sky130_fd_sc_hd__decap_6
XFILLER_49_253 VGND VGND VPWR VPWR sky130_fd_sc_hd__fill_2
XFILLER_37_7 VGND VGND VPWR VPWR sky130_fd_sc_hd__decap_3
XFILLER_2_55 VGND VGND VPWR VPWR sky130_fd_sc_hd__fill_2
XFILLER_1_293 VGND VGND VPWR VPWR sky130_fd_sc_hd__decap_3
X_1171_ clknet_3_2__leaf_clk _0039_ net139 VGND VGND VPWR VPWR ten_h\[3\] sky130_fd_sc_hd__dfrtp_2
XFILLER_17_183 VPWR VGND VPWR VGND sky130_ef_sc_hd__decap_12
X_0886_ net134 _0339_ _0345_ VGND VGND VPWR VPWR _0349_ sky130_fd_sc_hd__a21oi_1
X_0955_ net131 net130 _0315_ _0403_ VGND VGND VPWR VPWR _0404_ sky130_fd_sc_hd__and4b_1
XFILLER_32_197 VPWR VGND VPWR VGND sky130_ef_sc_hd__decap_12
XFILLER_32_153 VPWR VGND VPWR VGND sky130_ef_sc_hd__decap_12
Xoutput101 net101 VGND VGND VPWR VPWR led_unit_y[6] sky130_fd_sc_hd__buf_2
XFILLER_23_197 VGND VGND VPWR VPWR sky130_fd_sc_hd__fill_1
XFILLER_46_289 VGND VGND VPWR VPWR sky130_fd_sc_hd__decap_4
XFILLER_14_153 VPWR VGND VPWR VGND sky130_ef_sc_hd__decap_12
XFILLER_14_197 VGND VGND VPWR VPWR sky130_fd_sc_hd__decap_4
X_0740_ hour_counter_alarm.ten_h_alarm\[3\] net109 _0251_ VGND VGND VPWR VPWR _0252_
+ sky130_fd_sc_hd__a21oi_2
X_0671_ top_counter.min_counter.c0 _0192_ _0197_ net116 VGND VGND VPWR VPWR _0201_
+ sky130_fd_sc_hd__a22o_1
X_1154_ clknet_3_5__leaf_clk _0022_ net141 VGND VGND VPWR VPWR ten_mo\[2\] sky130_fd_sc_hd__dfrtp_4
X_1223_ net10 VGND VGND VPWR VPWR net9 sky130_fd_sc_hd__clkbuf_1
XFILLER_37_289 VGND VGND VPWR VPWR sky130_fd_sc_hd__decap_3
XFILLER_32_19 VGND VGND VPWR VPWR sky130_fd_sc_hd__decap_8
X_1085_ hour_counter_alarm.ten_h_alarm\[1\] _0485_ hour_counter_alarm.ten_h_alarm\[2\]
+ VGND VGND VPWR VPWR _0488_ sky130_fd_sc_hd__a21oi_1
X_0869_ net135 net132 net133 _0337_ VGND VGND VPWR VPWR net18 sky130_fd_sc_hd__o31ai_1
X_0938_ _0376_ _0379_ _0380_ _0094_ VGND VGND VPWR VPWR _0391_ sky130_fd_sc_hd__a31o_1
XFILLER_9_190 VGND VGND VPWR VPWR sky130_fd_sc_hd__decap_4
XTAP_TAPCELL_ROW_15_181 VGND VPWR sky130_fd_sc_hd__tapvpwrvgnd_1
XTAP_TAPCELL_ROW_38_295 VGND VPWR sky130_fd_sc_hd__tapvpwrvgnd_1
XFILLER_7_138 VPWR VGND VPWR VGND sky130_ef_sc_hd__decap_12
XFILLER_11_189 VGND VGND VPWR VPWR sky130_fd_sc_hd__decap_6
XFILLER_22_41 VPWR VGND VPWR VGND sky130_ef_sc_hd__decap_12
XFILLER_19_256 VGND VGND VPWR VPWR sky130_fd_sc_hd__decap_3
XTAP_TAPCELL_ROW_29_251 VGND VPWR sky130_fd_sc_hd__tapvpwrvgnd_1
X_0723_ net119 net121 VGND VGND VPWR VPWR _0240_ sky130_fd_sc_hd__nand2b_1
X_0585_ top_counter.second_counter.unit_s\[1\] _0137_ top_counter.second_counter.unit_s\[2\]
+ VGND VGND VPWR VPWR _0139_ sky130_fd_sc_hd__mux2_1
X_0654_ _0089_ _0184_ _0185_ _0189_ VGND VGND VPWR VPWR net85 sky130_fd_sc_hd__o211ai_1
X_1137_ clknet_3_7__leaf_clk _0005_ net143 VGND VGND VPWR VPWR hun_y\[1\] sky130_fd_sc_hd__dfrtp_1
X_1206_ clknet_3_1__leaf_clk _0067_ net137 VGND VGND VPWR VPWR control_unit.mode_alarm\[1\]
+ sky130_fd_sc_hd__dfrtp_1
XFILLER_33_281 VPWR VGND VPWR VGND sky130_ef_sc_hd__decap_12
X_1068_ net114 net113 _0468_ net112 VGND VGND VPWR VPWR _0475_ sky130_fd_sc_hd__a31o_1
XFILLER_3_130 VGND VGND VPWR VPWR sky130_fd_sc_hd__fill_2
XTAP_TAPCELL_ROW_49_357 VGND VPWR sky130_fd_sc_hd__tapvpwrvgnd_1
Xhold3 top_counter.day_in_month_decode.unit_mo\[2\] VGND VGND VPWR VPWR net157 sky130_fd_sc_hd__dlygate4sd3_1
XTAP_TAPCELL_ROW_32_268 VGND VPWR sky130_fd_sc_hd__tapvpwrvgnd_1
XFILLER_30_251 VGND VGND VPWR VPWR sky130_fd_sc_hd__fill_1
XFILLER_15_281 VPWR VGND VPWR VGND sky130_ef_sc_hd__decap_12
XFILLER_22_218 VPWR VGND VPWR VGND sky130_ef_sc_hd__decap_12
XFILLER_30_284 VGND VGND VPWR VPWR sky130_fd_sc_hd__decap_8
X_0706_ _0222_ _0226_ VGND VGND VPWR VPWR _0229_ sky130_fd_sc_hd__and2_1
X_0637_ net128 _0165_ _0174_ net129 VGND VGND VPWR VPWR net100 sky130_fd_sc_hd__o31a_1
XFILLER_38_29 VGND VGND VPWR VPWR sky130_fd_sc_hd__fill_2
X_0568_ top_counter.min_counter.c0 min_counter_alarm.unit_m_alarm\[0\] VGND VGND VPWR
+ VPWR _0123_ sky130_fd_sc_hd__and2b_1
XTAP_TAPCELL_ROW_0_100 VGND VPWR sky130_fd_sc_hd__tapvpwrvgnd_1
XFILLER_21_295 VGND VGND VPWR VPWR sky130_fd_sc_hd__fill_1
XTAP_TAPCELL_ROW_23_224 VGND VPWR sky130_fd_sc_hd__tapvpwrvgnd_1
XFILLER_0_133 VGND VGND VPWR VPWR sky130_fd_sc_hd__decap_3
XTAP_TAPCELL_ROW_46_338 VGND VPWR sky130_fd_sc_hd__tapvpwrvgnd_1
XFILLER_0_188 VGND VGND VPWR VPWR sky130_fd_sc_hd__decap_4
XFILLER_44_61 VPWR VGND VPWR VGND sky130_ef_sc_hd__decap_12
XFILLER_5_55 VGND VGND VPWR VPWR sky130_fd_sc_hd__fill_1
XFILLER_8_277 VPWR VGND VPWR VGND sky130_ef_sc_hd__decap_12
XFILLER_10_3 VPWR VGND VPWR VGND sky130_ef_sc_hd__decap_12
XFILLER_40_19 VGND VGND VPWR VPWR sky130_fd_sc_hd__decap_8
XTAP_TAPCELL_ROW_20_205 VGND VPWR sky130_fd_sc_hd__tapvpwrvgnd_1
XFILLER_5_269 VGND VGND VPWR VPWR sky130_fd_sc_hd__decap_8
XFILLER_5_225 VGND VGND VPWR VPWR sky130_fd_sc_hd__decap_8
XFILLER_29_181 VGND VGND VPWR VPWR sky130_fd_sc_hd__decap_8
XFILLER_44_195 VGND VGND VPWR VPWR sky130_fd_sc_hd__fill_1
X_0971_ _0319_ _0404_ _0407_ VGND VGND VPWR VPWR _0415_ sky130_fd_sc_hd__o21ai_1
XFILLER_41_187 VGND VGND VPWR VPWR sky130_fd_sc_hd__decap_8
XFILLER_41_73 VGND VGND VPWR VPWR sky130_fd_sc_hd__decap_3
XFILLER_49_210 VGND VGND VPWR VPWR sky130_fd_sc_hd__decap_3
XFILLER_2_78 VGND VGND VPWR VPWR sky130_fd_sc_hd__decap_3
X_1170_ clknet_3_3__leaf_clk _0038_ net140 VGND VGND VPWR VPWR ten_h\[2\] sky130_fd_sc_hd__dfrtp_2
XFILLER_32_165 VPWR VGND VPWR VGND sky130_ef_sc_hd__decap_12
XFILLER_32_121 VPWR VGND VPWR VGND sky130_ef_sc_hd__decap_12
XFILLER_17_195 VGND VGND VPWR VPWR sky130_fd_sc_hd__decap_6
X_0885_ net132 _0344_ net133 VGND VGND VPWR VPWR net23 sky130_fd_sc_hd__o21a_1
X_0954_ net129 net128 _0174_ VGND VGND VPWR VPWR _0403_ sky130_fd_sc_hd__and3b_1
XFILLER_46_29 VPWR VGND VPWR VGND sky130_ef_sc_hd__decap_12
XFILLER_11_65 VGND VGND VPWR VPWR sky130_fd_sc_hd__fill_2
XFILLER_14_121 VPWR VGND VPWR VGND sky130_ef_sc_hd__decap_12
X_0670_ _0080_ net116 _0200_ top_counter.min_counter.c0 _0195_ VGND VGND VPWR VPWR
+ net76 sky130_fd_sc_hd__a221o_1
XFILLER_14_165 VPWR VGND VPWR VGND sky130_ef_sc_hd__decap_12
XFILLER_37_268 VPWR VGND VPWR VGND sky130_ef_sc_hd__decap_12
X_1153_ clknet_3_5__leaf_clk _0021_ net142 VGND VGND VPWR VPWR ten_mo\[1\] sky130_fd_sc_hd__dfrtp_1
X_1222_ net154 VGND VGND VPWR VPWR led_am_pm[3] sky130_fd_sc_hd__buf_2
X_1084_ hour_counter_alarm.ten_h_alarm\[1\] _0485_ _0487_ VGND VGND VPWR VPWR _0049_
+ sky130_fd_sc_hd__o21a_1
XTAP_TAPCELL_ROW_15_182 VGND VPWR sky130_fd_sc_hd__tapvpwrvgnd_1
X_0868_ net133 _0336_ _0335_ VGND VGND VPWR VPWR _0337_ sky130_fd_sc_hd__o21ai_1
X_0799_ _0092_ _0093_ _0280_ _0292_ VGND VGND VPWR VPWR net43 sky130_fd_sc_hd__a31o_1
X_0937_ _0094_ _0376_ _0379_ _0380_ VGND VGND VPWR VPWR _0390_ sky130_fd_sc_hd__nand4_1
XTAP_TAPCELL_ROW_38_296 VGND VPWR sky130_fd_sc_hd__tapvpwrvgnd_1
XFILLER_7_117 VGND VGND VPWR VPWR sky130_fd_sc_hd__fill_1
XFILLER_11_113 VGND VGND VPWR VPWR sky130_fd_sc_hd__fill_1
XFILLER_11_146 VGND VGND VPWR VPWR sky130_fd_sc_hd__fill_2
XFILLER_22_53 VPWR VGND VPWR VGND sky130_ef_sc_hd__decap_12
XTAP_TAPCELL_ROW_29_252 VGND VPWR sky130_fd_sc_hd__tapvpwrvgnd_1
Xclkbuf_3_4__f_clk clknet_0_clk VGND VGND VPWR VPWR clknet_3_4__leaf_clk sky130_fd_sc_hd__clkbuf_16
XFILLER_27_290 VGND VGND VPWR VPWR sky130_fd_sc_hd__fill_2
X_0722_ _0234_ _0239_ _0237_ VGND VGND VPWR VPWR net61 sky130_fd_sc_hd__o21a_1
X_0653_ net127 net125 net124 net126 VGND VGND VPWR VPWR _0189_ sky130_fd_sc_hd__or4b_2
X_0584_ top_counter.second_counter.unit_s\[2\] _0137_ VGND VGND VPWR VPWR _0138_ sky130_fd_sc_hd__nand2_1
X_1136_ clknet_3_7__leaf_clk _0004_ net143 VGND VGND VPWR VPWR hun_y\[0\] sky130_fd_sc_hd__dfrtp_1
X_1067_ _0353_ _0355_ _0466_ VGND VGND VPWR VPWR _0474_ sky130_fd_sc_hd__or3_1
X_1205_ clknet_3_1__leaf_clk _0066_ net137 VGND VGND VPWR VPWR control_unit.mode_alarm\[0\]
+ sky130_fd_sc_hd__dfrtp_1
XFILLER_33_293 VGND VGND VPWR VPWR sky130_fd_sc_hd__decap_3
XTAP_TAPCELL_ROW_3_120 VGND VPWR sky130_fd_sc_hd__tapvpwrvgnd_1
XFILLER_17_31 VGND VGND VPWR VPWR sky130_fd_sc_hd__decap_8
XFILLER_31_208 VPWR VGND VPWR VGND sky130_ef_sc_hd__decap_12
XFILLER_3_197 VGND VGND VPWR VPWR sky130_fd_sc_hd__fill_1
XFILLER_3_153 VGND VGND VPWR VPWR sky130_fd_sc_hd__fill_1
Xhold4 ten_h\[3\] VGND VGND VPWR VPWR net158 sky130_fd_sc_hd__dlygate4sd3_1
XTAP_TAPCELL_ROW_49_358 VGND VPWR sky130_fd_sc_hd__tapvpwrvgnd_1
XTAP_TAPCELL_ROW_32_269 VGND VPWR sky130_fd_sc_hd__tapvpwrvgnd_1
XFILLER_15_293 VGND VGND VPWR VPWR sky130_fd_sc_hd__decap_3
X_0636_ _0165_ _0175_ _0177_ net128 VGND VGND VPWR VPWR net99 sky130_fd_sc_hd__a22o_1
X_0705_ _0218_ _0222_ _0228_ _0227_ _0214_ VGND VGND VPWR VPWR net69 sky130_fd_sc_hd__o32a_1
XTAP_TAPCELL_ROW_0_101 VGND VPWR sky130_fd_sc_hd__tapvpwrvgnd_1
X_0567_ hour_counter_alarm.unit_h_alarm\[2\] top_counter.hour_counter.unit_h\[2\]
+ VGND VGND VPWR VPWR _0122_ sky130_fd_sc_hd__and2b_1
XFILLER_13_208 VPWR VGND VPWR VGND sky130_ef_sc_hd__decap_12
X_1119_ _0076_ _0077_ _0503_ _0506_ _0502_ VGND VGND VPWR VPWR _0065_ sky130_fd_sc_hd__o311a_1
XPHY_EDGE_ROW_17_Right_17 VGND VGND VPWR VPWR sky130_fd_sc_hd__decap_3
XPHY_EDGE_ROW_26_Right_26 VGND VGND VPWR VPWR sky130_fd_sc_hd__decap_3
XTAP_TAPCELL_ROW_46_339 VGND VPWR sky130_fd_sc_hd__tapvpwrvgnd_1
XFILLER_28_41 VGND VGND VPWR VPWR sky130_fd_sc_hd__decap_6
XFILLER_44_73 VGND VGND VPWR VPWR sky130_fd_sc_hd__decap_4
XPHY_EDGE_ROW_35_Right_35 VGND VGND VPWR VPWR sky130_fd_sc_hd__decap_3
XFILLER_12_274 VPWR VGND VPWR VGND sky130_ef_sc_hd__decap_12
XFILLER_8_289 VGND VGND VPWR VPWR sky130_fd_sc_hd__decap_6
XPHY_EDGE_ROW_44_Right_44 VGND VGND VPWR VPWR sky130_fd_sc_hd__decap_3
XFILLER_39_105 VGND VGND VPWR VPWR sky130_fd_sc_hd__fill_2
XPHY_EDGE_ROW_17_Left_67 VGND VGND VPWR VPWR sky130_fd_sc_hd__decap_3
XTAP_TAPCELL_ROW_20_206 VGND VPWR sky130_fd_sc_hd__tapvpwrvgnd_1
XFILLER_49_29 VPWR VGND VPWR VGND sky130_ef_sc_hd__decap_12
X_0619_ top_counter.leap_year_check.u\[0\] top_counter.leap_year_check.u\[1\] VGND
+ VGND VPWR VPWR _0166_ sky130_fd_sc_hd__and2_1
XFILLER_30_20 VGND VGND VPWR VPWR sky130_fd_sc_hd__decap_3
XFILLER_30_42 VGND VGND VPWR VPWR sky130_fd_sc_hd__decap_8
XFILLER_30_64 VGND VGND VPWR VPWR sky130_fd_sc_hd__fill_1
XFILLER_39_40 VPWR VGND VPWR VGND sky130_ef_sc_hd__decap_12
XFILLER_44_141 VGND VGND VPWR VPWR sky130_fd_sc_hd__decap_4
X_0970_ ten_y\[0\] _0414_ _0413_ VGND VGND VPWR VPWR _0008_ sky130_fd_sc_hd__mux2_1
XFILLER_26_141 VPWR VGND VPWR VGND sky130_ef_sc_hd__decap_12
XFILLER_41_96 VGND VGND VPWR VPWR sky130_fd_sc_hd__decap_3
XFILLER_1_251 VPWR VGND VPWR VGND sky130_ef_sc_hd__decap_12
XFILLER_32_177 VPWR VGND VPWR VGND sky130_ef_sc_hd__decap_12
XFILLER_32_133 VGND VGND VPWR VPWR sky130_fd_sc_hd__decap_6
X_0884_ _0336_ _0340_ _0348_ net132 VGND VGND VPWR VPWR net22 sky130_fd_sc_hd__a22o_1
X_0953_ net1 control_unit.select_time\[5\] _0399_ _0400_ VGND VGND VPWR VPWR _0402_
+ sky130_fd_sc_hd__o2bb2ai_2
XFILLER_23_111 VGND VGND VPWR VPWR sky130_fd_sc_hd__fill_1
XFILLER_23_122 VPWR VGND VPWR VGND sky130_ef_sc_hd__decap_12
XFILLER_11_55 VGND VGND VPWR VPWR sky130_fd_sc_hd__fill_1
XFILLER_36_41 VGND VGND VPWR VPWR sky130_fd_sc_hd__decap_4
XFILLER_14_133 VGND VGND VPWR VPWR sky130_fd_sc_hd__decap_6
XFILLER_14_177 VPWR VGND VPWR VGND sky130_ef_sc_hd__decap_12
X_1221_ net10 VGND VGND VPWR VPWR net8 sky130_fd_sc_hd__clkbuf_1
XFILLER_37_225 VPWR VGND VPWR VGND sky130_ef_sc_hd__decap_12
X_1152_ clknet_3_4__leaf_clk _0020_ net141 VGND VGND VPWR VPWR ten_mo\[0\] sky130_fd_sc_hd__dfrtp_4
X_1083_ hour_counter_alarm.ten_h_alarm\[1\] _0485_ _0484_ _0478_ VGND VGND VPWR VPWR
+ _0487_ sky130_fd_sc_hd__o2bb2a_1
X_0936_ net122 _0388_ VGND VGND VPWR VPWR _0389_ sky130_fd_sc_hd__xor2_1
XTAP_TAPCELL_ROW_15_183 VGND VPWR sky130_fd_sc_hd__tapvpwrvgnd_1
X_0867_ _0094_ net135 VGND VGND VPWR VPWR _0336_ sky130_fd_sc_hd__and2_1
X_0798_ net123 ten_mo\[0\] ten_mo\[3\] _0284_ VGND VGND VPWR VPWR _0292_ sky130_fd_sc_hd__a31o_1
XTAP_TAPCELL_ROW_38_297 VGND VPWR sky130_fd_sc_hd__tapvpwrvgnd_1
XFILLER_36_291 VGND VGND VPWR VPWR sky130_fd_sc_hd__fill_1
XFILLER_11_125 VGND VGND VPWR VPWR sky130_fd_sc_hd__fill_1
XFILLER_22_65 VPWR VGND VPWR VGND sky130_ef_sc_hd__decap_12
XPHY_EDGE_ROW_5_Left_55 VGND VGND VPWR VPWR sky130_fd_sc_hd__decap_3
XFILLER_0_3 VPWR VGND VPWR VGND sky130_ef_sc_hd__decap_12
XFILLER_19_225 VGND VGND VPWR VPWR sky130_fd_sc_hd__decap_3
XTAP_TAPCELL_ROW_29_253 VGND VPWR sky130_fd_sc_hd__tapvpwrvgnd_1
XFILLER_42_250 VGND VGND VPWR VPWR sky130_fd_sc_hd__fill_2
X_0721_ net120 _0238_ VGND VGND VPWR VPWR _0239_ sky130_fd_sc_hd__nor2_1
X_0583_ top_counter.second_counter.unit_s\[0\] top_counter.second_counter.unit_s\[1\]
+ VGND VGND VPWR VPWR _0137_ sky130_fd_sc_hd__nand2_1
X_0652_ net126 net124 _0188_ net125 _0186_ VGND VGND VPWR VPWR net84 sky130_fd_sc_hd__a221o_1
X_1204_ clknet_3_6__leaf_clk _0065_ net144 VGND VGND VPWR VPWR hour_counter_alarm.unit_h_alarm\[3\]
+ sky130_fd_sc_hd__dfrtp_4
X_1135_ clknet_3_5__leaf_clk _0003_ net141 VGND VGND VPWR VPWR ten_d\[3\] sky130_fd_sc_hd__dfrtp_1
XFILLER_40_209 VGND VGND VPWR VPWR sky130_fd_sc_hd__fill_1
XFILLER_33_261 VPWR VGND VPWR VGND sky130_ef_sc_hd__decap_12
X_1066_ net114 ten_s\[1\] net112 _0468_ VGND VGND VPWR VPWR _0473_ sky130_fd_sc_hd__and4_1
XPHY_EDGE_ROW_47_Left_97 VGND VGND VPWR VPWR sky130_fd_sc_hd__decap_3
X_0919_ _0371_ VGND VGND VPWR VPWR _0372_ sky130_fd_sc_hd__inv_2
XTAP_TAPCELL_ROW_3_121 VGND VPWR sky130_fd_sc_hd__tapvpwrvgnd_1
XFILLER_3_110 VGND VGND VPWR VPWR sky130_fd_sc_hd__fill_2
Xhold5 control_unit.select_time\[0\] VGND VGND VPWR VPWR net159 sky130_fd_sc_hd__dlygate4sd3_1
XTAP_TAPCELL_ROW_49_359 VGND VPWR sky130_fd_sc_hd__tapvpwrvgnd_1
XFILLER_30_253 VPWR VGND VPWR VGND sky130_ef_sc_hd__decap_12
X_0635_ top_counter.leap_year_check.u\[2\] _0166_ VGND VGND VPWR VPWR _0177_ sky130_fd_sc_hd__or2_1
X_0566_ ten_h\[1\] hour_counter_alarm.ten_h_alarm\[1\] VGND VGND VPWR VPWR _0121_
+ sky130_fd_sc_hd__and2b_1
X_0704_ _0208_ _0209_ _0214_ VGND VGND VPWR VPWR _0228_ sky130_fd_sc_hd__nor3b_1
XTAP_TAPCELL_ROW_0_102 VGND VPWR sky130_fd_sc_hd__tapvpwrvgnd_1
X_1049_ _0462_ _0463_ VGND VGND VPWR VPWR _0038_ sky130_fd_sc_hd__nor2_1
X_1118_ hour_counter_alarm.unit_h_alarm\[2\] _0477_ _0480_ hour_counter_alarm.unit_h_alarm\[3\]
+ VGND VGND VPWR VPWR _0506_ sky130_fd_sc_hd__a31o_1
XFILLER_48_106 VGND VGND VPWR VPWR sky130_fd_sc_hd__fill_1
XFILLER_0_113 VGND VGND VPWR VPWR sky130_fd_sc_hd__fill_2
XFILLER_44_41 VGND VGND VPWR VPWR sky130_fd_sc_hd__fill_1
XFILLER_44_85 VPWR VGND VPWR VGND sky130_ef_sc_hd__decap_12
XFILLER_12_286 VGND VGND VPWR VPWR sky130_fd_sc_hd__decap_8
XFILLER_5_57 VPWR VGND VPWR VGND sky130_ef_sc_hd__decap_12
XTAP_TAPCELL_ROW_20_207 VGND VPWR sky130_fd_sc_hd__tapvpwrvgnd_1
X_0618_ top_counter.leap_year_check.u\[0\] top_counter.leap_year_check.u\[1\] VGND
+ VGND VPWR VPWR _0165_ sky130_fd_sc_hd__and2b_1
X_0549_ net117 min_counter_alarm.ten_m_alarm\[0\] VGND VGND VPWR VPWR _0104_ sky130_fd_sc_hd__and2b_1
XFILLER_38_183 VGND VGND VPWR VPWR sky130_fd_sc_hd__decap_3
XFILLER_14_44 VGND VGND VPWR VPWR sky130_fd_sc_hd__fill_1
XFILLER_14_66 VPWR VGND VPWR VGND sky130_ef_sc_hd__decap_12
XFILLER_39_52 VGND VGND VPWR VPWR sky130_fd_sc_hd__decap_4
XPHY_EDGE_ROW_34_Left_84 VGND VGND VPWR VPWR sky130_fd_sc_hd__decap_3
XFILLER_29_161 VGND VGND VPWR VPWR sky130_fd_sc_hd__decap_6
XFILLER_44_197 VPWR VGND VPWR VGND sky130_ef_sc_hd__decap_12
XFILLER_26_153 VPWR VGND VPWR VGND sky130_ef_sc_hd__decap_12
XFILLER_26_197 VPWR VGND VPWR VGND sky130_ef_sc_hd__decap_12
XFILLER_1_263 VPWR VGND VPWR VGND sky130_ef_sc_hd__decap_12
XFILLER_49_278 VGND VGND VPWR VPWR sky130_fd_sc_hd__fill_2
XFILLER_49_245 VGND VGND VPWR VPWR sky130_fd_sc_hd__decap_6
X_0952_ _0189_ _0290_ VGND VGND VPWR VPWR _0401_ sky130_fd_sc_hd__nor2_1
XFILLER_32_189 VGND VGND VPWR VPWR sky130_fd_sc_hd__decap_6
XFILLER_17_175 VGND VGND VPWR VPWR sky130_fd_sc_hd__decap_4
X_0883_ ten_d\[0\] net135 net134 VGND VGND VPWR VPWR _0348_ sky130_fd_sc_hd__a21o_1
XFILLER_23_134 VPWR VGND VPWR VGND sky130_ef_sc_hd__decap_12
XFILLER_23_178 VGND VGND VPWR VPWR sky130_fd_sc_hd__fill_1
XFILLER_14_189 VGND VGND VPWR VPWR sky130_fd_sc_hd__decap_6
XFILLER_35_7 VGND VGND VPWR VPWR sky130_fd_sc_hd__fill_2
X_1220_ net10 VGND VGND VPWR VPWR net7 sky130_fd_sc_hd__clkbuf_1
X_1151_ clknet_3_4__leaf_clk _0019_ net142 VGND VGND VPWR VPWR top_counter.day_in_month_decode.unit_mo\[3\]
+ sky130_fd_sc_hd__dfrtp_1
XFILLER_45_281 VPWR VGND VPWR VGND sky130_ef_sc_hd__decap_12
XFILLER_37_237 VGND VGND VPWR VPWR sky130_fd_sc_hd__fill_1
X_1082_ net167 _0483_ _0486_ VGND VGND VPWR VPWR _0048_ sky130_fd_sc_hd__o21a_1
X_0866_ ten_d\[0\] ten_d\[1\] net132 VGND VGND VPWR VPWR _0335_ sky130_fd_sc_hd__a21o_1
X_0935_ _0382_ _0387_ _0376_ _0381_ VGND VGND VPWR VPWR _0388_ sky130_fd_sc_hd__o211a_1
XTAP_TAPCELL_ROW_15_184 VGND VPWR sky130_fd_sc_hd__tapvpwrvgnd_1
XFILLER_20_148 VPWR VGND VPWR VGND sky130_ef_sc_hd__decap_12
XPHY_EDGE_ROW_21_Left_71 VGND VGND VPWR VPWR sky130_fd_sc_hd__decap_3
X_0797_ net123 ten_mo\[3\] ten_mo\[2\] _0289_ _0291_ VGND VGND VPWR VPWR net42 sky130_fd_sc_hd__a221o_1
XFILLER_3_90 VGND VGND VPWR VPWR sky130_fd_sc_hd__fill_1
XTAP_TAPCELL_ROW_38_298 VGND VPWR sky130_fd_sc_hd__tapvpwrvgnd_1
XFILLER_22_77 VGND VGND VPWR VPWR sky130_fd_sc_hd__decap_6
XTAP_TAPCELL_ROW_29_254 VGND VPWR sky130_fd_sc_hd__tapvpwrvgnd_1
X_0720_ top_counter.day_counter.unit_d\[0\] net121 VGND VGND VPWR VPWR _0238_ sky130_fd_sc_hd__nor2_1
XTAP_TAPCELL_ROW_12_165 VGND VPWR sky130_fd_sc_hd__tapvpwrvgnd_1
X_0582_ net111 _0107_ _0115_ _0136_ VGND VGND VPWR VPWR net5 sky130_fd_sc_hd__nor4_1
X_0651_ net124 _0187_ VGND VGND VPWR VPWR _0188_ sky130_fd_sc_hd__nor2_1
X_1134_ clknet_3_5__leaf_clk _0002_ net141 VGND VGND VPWR VPWR ten_d\[2\] sky130_fd_sc_hd__dfrtp_1
X_1203_ clknet_3_3__leaf_clk _0064_ net140 VGND VGND VPWR VPWR hour_counter_alarm.unit_h_alarm\[2\]
+ sky130_fd_sc_hd__dfrtp_2
XFILLER_33_273 VGND VGND VPWR VPWR sky130_fd_sc_hd__decap_6
X_1065_ _0328_ _0352_ _0468_ _0471_ net156 VGND VGND VPWR VPWR _0045_ sky130_fd_sc_hd__a32o_1
XFILLER_18_281 VGND VGND VPWR VPWR sky130_fd_sc_hd__decap_8
X_0918_ net122 net119 _0244_ VGND VGND VPWR VPWR _0371_ sky130_fd_sc_hd__and3_1
X_0849_ ten_s\[3\] net104 VGND VGND VPWR VPWR _0324_ sky130_fd_sc_hd__nor2_1
XTAP_TAPCELL_ROW_3_122 VGND VPWR sky130_fd_sc_hd__tapvpwrvgnd_1
XFILLER_17_55 VGND VGND VPWR VPWR sky130_fd_sc_hd__fill_1
XTAP_TAPCELL_ROW_26_235 VGND VPWR sky130_fd_sc_hd__tapvpwrvgnd_1
XFILLER_33_76 VPWR VGND VPWR VGND sky130_ef_sc_hd__decap_12
XFILLER_3_166 VGND VGND VPWR VPWR sky130_fd_sc_hd__fill_2
XFILLER_3_122 VGND VGND VPWR VPWR sky130_fd_sc_hd__decap_8
Xhold6 control_unit.select_time\[1\] VGND VGND VPWR VPWR net160 sky130_fd_sc_hd__dlygate4sd3_1
XFILLER_30_221 VPWR VGND VPWR VGND sky130_ef_sc_hd__decap_12
XFILLER_30_265 VGND VGND VPWR VPWR sky130_fd_sc_hd__decap_6
X_0703_ _0070_ _0222_ _0218_ VGND VGND VPWR VPWR _0227_ sky130_fd_sc_hd__a21bo_1
Xmax_cap103 _0209_ VGND VGND VPWR VPWR net103 sky130_fd_sc_hd__buf_1
X_0634_ net101 _0176_ _0172_ VGND VGND VPWR VPWR net98 sky130_fd_sc_hd__or3b_1
X_0565_ _0116_ _0117_ _0118_ _0119_ VGND VGND VPWR VPWR _0120_ sky130_fd_sc_hd__or4_1
XTAP_TAPCELL_ROW_0_103 VGND VPWR sky130_fd_sc_hd__tapvpwrvgnd_1
X_1117_ _0076_ _0503_ _0504_ _0505_ VGND VGND VPWR VPWR _0064_ sky130_fd_sc_hd__o211a_1
XTAP_TAPCELL_ROW_31_260 VGND VPWR sky130_fd_sc_hd__tapvpwrvgnd_1
XPHY_EDGE_ROW_3_Right_3 VGND VGND VPWR VPWR sky130_fd_sc_hd__decap_3
XFILLER_0_91 VGND VGND VPWR VPWR sky130_fd_sc_hd__decap_3
X_1048_ _0204_ _0455_ ten_h\[2\] VGND VGND VPWR VPWR _0463_ sky130_fd_sc_hd__a21oi_1
XFILLER_21_210 VPWR VGND VPWR VGND sky130_ef_sc_hd__decap_12
XFILLER_0_147 VGND VGND VPWR VPWR sky130_fd_sc_hd__decap_3
XFILLER_0_169 VGND VGND VPWR VPWR sky130_fd_sc_hd__fill_2
XFILLER_28_65 VPWR VGND VPWR VGND sky130_ef_sc_hd__decap_12
XFILLER_44_97 VPWR VGND VPWR VGND sky130_ef_sc_hd__decap_12
XFILLER_5_69 VPWR VGND VPWR VGND sky130_ef_sc_hd__decap_12
XFILLER_39_118 VPWR VGND VPWR VGND sky130_ef_sc_hd__decap_12
XTAP_TAPCELL_ROW_45_330 VGND VPWR sky130_fd_sc_hd__tapvpwrvgnd_1
XTAP_TAPCELL_ROW_20_208 VGND VPWR sky130_fd_sc_hd__tapvpwrvgnd_1
X_0548_ hour_counter_alarm.ten_h_alarm\[2\] ten_h\[2\] VGND VGND VPWR VPWR _0103_
+ sky130_fd_sc_hd__and2b_1
X_0617_ top_counter.second_counter.unit_s\[2\] _0158_ _0162_ _0156_ VGND VGND VPWR
+ VPWR net94 sky130_fd_sc_hd__o2bb2a_1
XFILLER_38_195 VGND VGND VPWR VPWR sky130_fd_sc_hd__fill_1
XFILLER_14_78 VGND VGND VPWR VPWR sky130_fd_sc_hd__decap_6
XFILLER_44_121 VPWR VGND VPWR VGND sky130_ef_sc_hd__decap_12
XFILLER_35_110 VGND VGND VPWR VPWR sky130_fd_sc_hd__fill_2
XFILLER_41_113 VGND VGND VPWR VPWR sky130_fd_sc_hd__decap_3
XFILLER_25_33 VGND VGND VPWR VPWR sky130_fd_sc_hd__fill_1
XFILLER_25_55 VGND VGND VPWR VPWR sky130_fd_sc_hd__fill_1
XFILLER_25_99 VGND VGND VPWR VPWR sky130_fd_sc_hd__decap_4
XFILLER_26_165 VGND VGND VPWR VPWR sky130_fd_sc_hd__decap_8
XFILLER_2_15 VPWR VGND VPWR VGND sky130_ef_sc_hd__decap_12
XFILLER_1_275 VGND VGND VPWR VPWR sky130_fd_sc_hd__decap_4
XFILLER_17_121 VGND VGND VPWR VPWR sky130_fd_sc_hd__decap_4
X_0882_ _0346_ _0347_ VGND VGND VPWR VPWR net21 sky130_fd_sc_hd__nand2_1
XFILLER_40_190 VGND VGND VPWR VPWR sky130_fd_sc_hd__decap_6
X_0951_ control_unit.select_time\[4\] _0381_ top_counter.day_in_month_decode.unit_mo\[1\]
+ VGND VGND VPWR VPWR _0400_ sky130_fd_sc_hd__or3b_1
XFILLER_23_146 VGND VGND VPWR VPWR sky130_fd_sc_hd__fill_1
XFILLER_11_57 VGND VGND VPWR VPWR sky130_fd_sc_hd__decap_8
XTAP_TAPCELL_ROW_9_150 VGND VPWR sky130_fd_sc_hd__tapvpwrvgnd_1
X_1150_ clknet_3_4__leaf_clk _0018_ net142 VGND VGND VPWR VPWR top_counter.day_in_month_decode.unit_mo\[2\]
+ sky130_fd_sc_hd__dfrtp_2
XFILLER_28_7 VGND VGND VPWR VPWR sky130_fd_sc_hd__decap_3
XFILLER_45_293 VGND VGND VPWR VPWR sky130_fd_sc_hd__decap_3
X_1081_ _0478_ _0484_ _0485_ VGND VGND VPWR VPWR _0486_ sky130_fd_sc_hd__o21ba_1
X_0934_ _0088_ _0165_ _0386_ VGND VGND VPWR VPWR _0387_ sky130_fd_sc_hd__o21ai_1
X_0865_ _0324_ _0329_ _0331_ _0326_ VGND VGND VPWR VPWR net52 sky130_fd_sc_hd__a31o_1
XFILLER_9_161 VGND VGND VPWR VPWR sky130_fd_sc_hd__decap_6
X_0796_ _0284_ _0290_ VGND VGND VPWR VPWR _0291_ sky130_fd_sc_hd__nand2b_1
XFILLER_28_238 VPWR VGND VPWR VGND sky130_ef_sc_hd__decap_12
XTAP_TAPCELL_ROW_38_299 VGND VPWR sky130_fd_sc_hd__tapvpwrvgnd_1
XFILLER_47_64 VGND VGND VPWR VPWR sky130_fd_sc_hd__fill_2
Xfanout140 net145 VGND VGND VPWR VPWR net140 sky130_fd_sc_hd__buf_2
XTAP_TAPCELL_ROW_12_166 VGND VPWR sky130_fd_sc_hd__tapvpwrvgnd_1
X_0581_ _0120_ _0125_ _0130_ _0135_ VGND VGND VPWR VPWR _0136_ sky130_fd_sc_hd__or4_1
X_0650_ net127 net126 VGND VGND VPWR VPWR _0187_ sky130_fd_sc_hd__xor2_1
X_1133_ clknet_3_5__leaf_clk _0001_ net141 VGND VGND VPWR VPWR ten_d\[1\] sky130_fd_sc_hd__dfrtp_1
X_1064_ _0471_ _0472_ VGND VGND VPWR VPWR _0044_ sky130_fd_sc_hd__and2_1
X_1202_ clknet_3_6__leaf_clk _0063_ net144 VGND VGND VPWR VPWR hour_counter_alarm.unit_h_alarm\[1\]
+ sky130_fd_sc_hd__dfrtp_1
XFILLER_25_219 VGND VGND VPWR VPWR sky130_fd_sc_hd__fill_1
X_0779_ top_counter.min_counter.t2 net115 VGND VGND VPWR VPWR _0279_ sky130_fd_sc_hd__and2b_1
X_0848_ net104 _0323_ VGND VGND VPWR VPWR net46 sky130_fd_sc_hd__or2_1
X_0917_ _0087_ _0368_ _0369_ _0365_ VGND VGND VPWR VPWR _0370_ sky130_fd_sc_hd__a31o_1
XTAP_TAPCELL_ROW_3_123 VGND VPWR sky130_fd_sc_hd__tapvpwrvgnd_1
XTAP_TAPCELL_ROW_26_236 VGND VPWR sky130_fd_sc_hd__tapvpwrvgnd_1
XFILLER_33_88 VPWR VGND VPWR VGND sky130_ef_sc_hd__decap_12
XFILLER_33_55 VGND VGND VPWR VPWR sky130_fd_sc_hd__fill_1
Xhold7 control_unit.select_time\[5\] VGND VGND VPWR VPWR net161 sky130_fd_sc_hd__dlygate4sd3_1
XFILLER_30_233 VPWR VGND VPWR VGND sky130_ef_sc_hd__decap_12
X_0633_ top_counter.leap_year_check.u\[0\] top_counter.leap_year_check.u\[1\] net129
+ VGND VGND VPWR VPWR _0176_ sky130_fd_sc_hd__and3_1
X_0702_ _0218_ _0225_ _0226_ _0224_ VGND VGND VPWR VPWR net68 sky130_fd_sc_hd__a31o_1
X_0564_ hour_counter_alarm.unit_h_alarm\[3\] top_counter.hour_counter.unit_h\[3\]
+ VGND VGND VPWR VPWR _0119_ sky130_fd_sc_hd__and2b_1
XFILLER_0_70 VGND VGND VPWR VPWR sky130_fd_sc_hd__decap_3
XTAP_TAPCELL_ROW_0_104 VGND VPWR sky130_fd_sc_hd__tapvpwrvgnd_1
X_1047_ ten_h\[2\] _0204_ _0455_ VGND VGND VPWR VPWR _0462_ sky130_fd_sc_hd__and3_1
X_1116_ hour_counter_alarm.unit_h_alarm\[2\] _0478_ _0484_ _0476_ VGND VGND VPWR VPWR
+ _0505_ sky130_fd_sc_hd__a22o_1
XTAP_TAPCELL_ROW_31_261 VGND VPWR sky130_fd_sc_hd__tapvpwrvgnd_1
XFILLER_21_222 VGND VGND VPWR VPWR sky130_fd_sc_hd__fill_2
XFILLER_0_126 VGND VGND VPWR VPWR sky130_fd_sc_hd__decap_3
XFILLER_28_77 VGND VGND VPWR VPWR sky130_fd_sc_hd__decap_6
XFILLER_5_15 VPWR VGND VPWR VGND sky130_ef_sc_hd__decap_12
XTAP_TAPCELL_ROW_45_331 VGND VPWR sky130_fd_sc_hd__tapvpwrvgnd_1
XPHY_EDGE_ROW_13_Right_13 VGND VGND VPWR VPWR sky130_fd_sc_hd__decap_3
XTAP_TAPCELL_ROW_20_209 VGND VPWR sky130_fd_sc_hd__tapvpwrvgnd_1
XPHY_EDGE_ROW_22_Right_22 VGND VGND VPWR VPWR sky130_fd_sc_hd__decap_3
XFILLER_7_281 VPWR VGND VPWR VGND sky130_ef_sc_hd__decap_12
X_0616_ _0156_ _0161_ VGND VGND VPWR VPWR net93 sky130_fd_sc_hd__nand2b_1
XFILLER_38_141 VPWR VGND VPWR VGND sky130_ef_sc_hd__decap_12
XPHY_EDGE_ROW_31_Right_31 VGND VGND VPWR VPWR sky130_fd_sc_hd__decap_3
X_0547_ ten_h\[2\] hour_counter_alarm.ten_h_alarm\[2\] VGND VGND VPWR VPWR _0102_
+ sky130_fd_sc_hd__and2b_1
XPHY_EDGE_ROW_40_Right_40 VGND VGND VPWR VPWR sky130_fd_sc_hd__decap_3
XFILLER_44_133 VGND VGND VPWR VPWR sky130_fd_sc_hd__decap_6
XFILLER_44_177 VGND VGND VPWR VPWR sky130_fd_sc_hd__decap_3
XFILLER_4_251 VGND VGND VPWR VPWR sky130_fd_sc_hd__fill_1
XFILLER_4_295 VGND VGND VPWR VPWR sky130_fd_sc_hd__fill_1
XFILLER_26_111 VPWR VGND VPWR VGND sky130_ef_sc_hd__decap_12
XFILLER_41_136 VPWR VGND VPWR VGND sky130_ef_sc_hd__decap_12
XFILLER_25_78 VGND VGND VPWR VPWR sky130_fd_sc_hd__fill_1
XFILLER_49_258 VPWR VGND VPWR VGND sky130_ef_sc_hd__decap_12
XFILLER_49_225 VGND VGND VPWR VPWR sky130_fd_sc_hd__fill_2
XFILLER_49_203 VGND VGND VPWR VPWR sky130_fd_sc_hd__decap_3
XFILLER_2_27 VGND VGND VPWR VPWR sky130_fd_sc_hd__fill_1
X_0881_ net135 net133 net132 VGND VGND VPWR VPWR _0347_ sky130_fd_sc_hd__o21ai_1
X_0950_ _0385_ _0389_ _0392_ _0398_ VGND VGND VPWR VPWR _0399_ sky130_fd_sc_hd__nand4_1
XFILLER_49_3 VPWR VGND VPWR VGND sky130_ef_sc_hd__decap_12
XFILLER_46_228 VGND VGND VPWR VPWR sky130_fd_sc_hd__fill_1
XFILLER_22_180 VGND VGND VPWR VPWR sky130_fd_sc_hd__fill_2
XTAP_TAPCELL_ROW_9_151 VGND VPWR sky130_fd_sc_hd__tapvpwrvgnd_1
X_1080_ hour_counter_alarm.ten_h_alarm\[0\] _0477_ _0482_ VGND VGND VPWR VPWR _0485_
+ sky130_fd_sc_hd__and3_1
X_0933_ top_counter.leap_year_check.u\[0\] top_counter.leap_year_check.u\[1\] ten_y\[0\]
+ VGND VGND VPWR VPWR _0386_ sky130_fd_sc_hd__o21bai_1
X_0795_ net123 ten_mo\[3\] ten_mo\[2\] ten_mo\[0\] VGND VGND VPWR VPWR _0290_ sky130_fd_sc_hd__or4b_2
X_0864_ _0326_ _0332_ VGND VGND VPWR VPWR net51 sky130_fd_sc_hd__nand2b_1
XFILLER_11_106 VGND VGND VPWR VPWR sky130_fd_sc_hd__decap_3
Xfanout130 ten_y\[3\] VGND VGND VPWR VPWR net130 sky130_fd_sc_hd__clkbuf_2
Xfanout141 net142 VGND VGND VPWR VPWR net141 sky130_fd_sc_hd__clkbuf_4
XFILLER_42_253 VPWR VGND VPWR VGND sky130_ef_sc_hd__decap_12
XFILLER_34_209 VPWR VGND VPWR VGND sky130_ef_sc_hd__decap_12
XFILLER_8_15 VPWR VGND VPWR VGND sky130_ef_sc_hd__decap_12
XFILLER_10_172 VGND VGND VPWR VPWR sky130_fd_sc_hd__fill_1
XTAP_TAPCELL_ROW_12_167 VGND VPWR sky130_fd_sc_hd__tapvpwrvgnd_1
XFILLER_40_7 VPWR VGND VPWR VGND sky130_ef_sc_hd__decap_12
X_0580_ _0131_ _0132_ _0133_ _0134_ VGND VGND VPWR VPWR _0135_ sky130_fd_sc_hd__or4_1
X_1201_ clknet_3_6__leaf_clk _0062_ net140 VGND VGND VPWR VPWR hour_counter_alarm.unit_h_alarm\[0\]
+ sky130_fd_sc_hd__dfrtp_2
X_1132_ clknet_3_5__leaf_clk _0000_ net141 VGND VGND VPWR VPWR ten_d\[0\] sky130_fd_sc_hd__dfrtp_2
X_1063_ net114 _0468_ VGND VGND VPWR VPWR _0472_ sky130_fd_sc_hd__or2_1
XFILLER_18_261 VGND VGND VPWR VPWR sky130_fd_sc_hd__fill_1
X_0916_ net117 _0277_ _0356_ _0358_ VGND VGND VPWR VPWR _0369_ sky130_fd_sc_hd__and4_1
X_0847_ _0320_ _0321_ VGND VGND VPWR VPWR _0323_ sky130_fd_sc_hd__xnor2_1
X_0778_ _0274_ net38 VGND VGND VPWR VPWR net35 sky130_fd_sc_hd__or2_1
XTAP_TAPCELL_ROW_3_124 VGND VPWR sky130_fd_sc_hd__tapvpwrvgnd_1
XPHY_EDGE_ROW_9_Left_59 VGND VGND VPWR VPWR sky130_fd_sc_hd__decap_3
XFILLER_17_57 VPWR VGND VPWR VGND sky130_ef_sc_hd__decap_12
XTAP_TAPCELL_ROW_26_237 VGND VPWR sky130_fd_sc_hd__tapvpwrvgnd_1
Xhold8 hun_y\[0\] VGND VGND VPWR VPWR net162 sky130_fd_sc_hd__dlygate4sd3_1
XFILLER_30_245 VGND VGND VPWR VPWR sky130_fd_sc_hd__decap_6
XFILLER_15_231 VGND VGND VPWR VPWR sky130_fd_sc_hd__decap_6
X_0632_ net129 _0170_ _0174_ _0175_ VGND VGND VPWR VPWR net101 sky130_fd_sc_hd__a22o_1
X_0563_ ten_h\[0\] hour_counter_alarm.ten_h_alarm\[0\] VGND VGND VPWR VPWR _0118_
+ sky130_fd_sc_hd__and2b_1
X_0701_ _0208_ net103 _0214_ VGND VGND VPWR VPWR _0226_ sky130_fd_sc_hd__or3_1
XTAP_TAPCELL_ROW_0_105 VGND VPWR sky130_fd_sc_hd__tapvpwrvgnd_1
X_1046_ _0204_ _0455_ _0461_ _0073_ _0458_ VGND VGND VPWR VPWR _0037_ sky130_fd_sc_hd__a221oi_1
X_1115_ hour_counter_alarm.unit_h_alarm\[2\] _0480_ VGND VGND VPWR VPWR _0504_ sky130_fd_sc_hd__or2_1
XTAP_TAPCELL_ROW_31_262 VGND VPWR sky130_fd_sc_hd__tapvpwrvgnd_1
XFILLER_0_105 VGND VGND VPWR VPWR sky130_fd_sc_hd__decap_3
XFILLER_5_27 VPWR VGND VPWR VGND sky130_ef_sc_hd__decap_12
XTAP_TAPCELL_ROW_45_332 VGND VPWR sky130_fd_sc_hd__tapvpwrvgnd_1
X_0546_ hour_counter_alarm.ten_h_alarm\[3\] ten_h\[3\] VGND VGND VPWR VPWR _0101_
+ sky130_fd_sc_hd__and2b_1
X_0615_ _0084_ _0163_ _0164_ VGND VGND VPWR VPWR net92 sky130_fd_sc_hd__mux2_1
XFILLER_38_175 VGND VGND VPWR VPWR sky130_fd_sc_hd__decap_8
XFILLER_38_153 VGND VGND VPWR VPWR sky130_fd_sc_hd__fill_1
X_1029_ net107 _0450_ VGND VGND VPWR VPWR _0031_ sky130_fd_sc_hd__nor2_1
XFILLER_14_25 VGND VGND VPWR VPWR sky130_fd_sc_hd__decap_3
XFILLER_14_36 VGND VGND VPWR VPWR sky130_fd_sc_hd__fill_1
XFILLER_30_13 VGND VGND VPWR VPWR sky130_fd_sc_hd__fill_1
XFILLER_39_33 VGND VGND VPWR VPWR sky130_fd_sc_hd__fill_1
XFILLER_39_11 VGND VGND VPWR VPWR sky130_fd_sc_hd__fill_1
XFILLER_35_167 VGND VGND VPWR VPWR sky130_fd_sc_hd__fill_1
X_0529_ top_counter.second_counter.unit_s\[3\] VGND VGND VPWR VPWR _0084_ sky130_fd_sc_hd__inv_2
XFILLER_26_123 VPWR VGND VPWR VGND sky130_ef_sc_hd__decap_12
XFILLER_41_148 VGND VGND VPWR VPWR sky130_fd_sc_hd__decap_3
XPHY_EDGE_ROW_38_Left_88 VGND VGND VPWR VPWR sky130_fd_sc_hd__decap_3
XFILLER_1_211 VGND VGND VPWR VPWR sky130_fd_sc_hd__fill_2
XFILLER_9_3 VPWR VGND VPWR VGND sky130_ef_sc_hd__decap_12
XFILLER_17_167 VGND VGND VPWR VPWR sky130_fd_sc_hd__fill_1
X_0880_ net133 _0344_ _0345_ VGND VGND VPWR VPWR _0346_ sky130_fd_sc_hd__a21o_1
XFILLER_15_90 VGND VGND VPWR VPWR sky130_fd_sc_hd__decap_8
XFILLER_31_181 VGND VGND VPWR VPWR sky130_fd_sc_hd__decap_6
XTAP_TAPCELL_ROW_18_195 VGND VPWR sky130_fd_sc_hd__tapvpwrvgnd_1
XFILLER_11_15 VPWR VGND VPWR VGND sky130_ef_sc_hd__decap_12
XFILLER_39_281 VGND VGND VPWR VPWR sky130_fd_sc_hd__decap_8
XFILLER_36_56 VPWR VGND VPWR VGND sky130_ef_sc_hd__decap_12
XFILLER_36_45 VGND VGND VPWR VPWR sky130_fd_sc_hd__fill_1
XTAP_TAPCELL_ROW_9_152 VGND VPWR sky130_fd_sc_hd__tapvpwrvgnd_1
X_0932_ net119 _0382_ _0383_ ten_d\[1\] _0384_ VGND VGND VPWR VPWR _0385_ sky130_fd_sc_hd__a221oi_1
XFILLER_13_181 VPWR VGND VPWR VGND sky130_ef_sc_hd__decap_12
X_0794_ _0280_ _0288_ VGND VGND VPWR VPWR _0289_ sky130_fd_sc_hd__nor2_1
X_0863_ _0086_ _0333_ _0334_ VGND VGND VPWR VPWR net50 sky130_fd_sc_hd__mux2_1
XFILLER_36_251 VGND VGND VPWR VPWR sky130_fd_sc_hd__fill_1
Xfanout131 ten_y\[2\] VGND VGND VPWR VPWR net131 sky130_fd_sc_hd__clkbuf_2
Xfanout120 top_counter.day_counter.unit_d\[2\] VGND VGND VPWR VPWR net120 sky130_fd_sc_hd__buf_2
Xfanout142 net145 VGND VGND VPWR VPWR net142 sky130_fd_sc_hd__clkbuf_4
XFILLER_27_251 VGND VGND VPWR VPWR sky130_fd_sc_hd__fill_1
XFILLER_42_265 VGND VGND VPWR VPWR sky130_fd_sc_hd__decap_6
XTAP_TAPCELL_ROW_37_290 VGND VPWR sky130_fd_sc_hd__tapvpwrvgnd_1
XFILLER_8_27 VGND VGND VPWR VPWR sky130_fd_sc_hd__fill_1
XFILLER_10_195 VGND VGND VPWR VPWR sky130_fd_sc_hd__fill_1
XTAP_TAPCELL_ROW_12_168 VGND VPWR sky130_fd_sc_hd__tapvpwrvgnd_1
XFILLER_33_7 VPWR VGND VPWR VGND sky130_ef_sc_hd__decap_12
X_1200_ clknet_3_4__leaf_clk _0061_ net142 VGND VGND VPWR VPWR control_unit.select_time\[5\]
+ sky130_fd_sc_hd__dfrtp_1
X_1062_ net114 _0468_ VGND VGND VPWR VPWR _0471_ sky130_fd_sc_hd__nand2_1
X_1131_ control_unit.mode_display\[1\] _0507_ _0512_ _0514_ VGND VGND VPWR VPWR _0069_
+ sky130_fd_sc_hd__o211a_1
XPHY_EDGE_ROW_25_Left_75 VGND VGND VPWR VPWR sky130_fd_sc_hd__decap_3
X_0915_ _0366_ _0367_ VGND VGND VPWR VPWR _0368_ sky130_fd_sc_hd__nor2_1
X_0846_ net114 net113 net112 VGND VGND VPWR VPWR _0322_ sky130_fd_sc_hd__a21bo_1
X_0777_ net34 _0278_ VGND VGND VPWR VPWR net38 sky130_fd_sc_hd__and2_1
XFILLER_33_57 VPWR VGND VPWR VGND sky130_ef_sc_hd__decap_12
XFILLER_17_69 VPWR VGND VPWR VGND sky130_ef_sc_hd__decap_12
XTAP_TAPCELL_ROW_26_238 VGND VPWR sky130_fd_sc_hd__tapvpwrvgnd_1
Xhold9 control_unit.mode_display\[0\] VGND VGND VPWR VPWR net163 sky130_fd_sc_hd__dlygate4sd3_1
X_0700_ _0215_ _0222_ VGND VGND VPWR VPWR _0225_ sky130_fd_sc_hd__nand2_1
XFILLER_15_254 VGND VGND VPWR VPWR sky130_fd_sc_hd__fill_2
X_0631_ net129 net128 VGND VGND VPWR VPWR _0175_ sky130_fd_sc_hd__nor2_1
X_0562_ min_counter_alarm.unit_m_alarm\[0\] top_counter.min_counter.c0 VGND VGND VPWR
+ VPWR _0117_ sky130_fd_sc_hd__and2b_1
XTAP_TAPCELL_ROW_0_106 VGND VPWR sky130_fd_sc_hd__tapvpwrvgnd_1
X_1114_ _0501_ _0502_ _0503_ VGND VGND VPWR VPWR _0063_ sky130_fd_sc_hd__and3_1
X_1045_ ten_h\[0\] _0455_ _0461_ VGND VGND VPWR VPWR _0036_ sky130_fd_sc_hd__o21a_1
X_0829_ ten_y\[0\] ten_y\[1\] VGND VGND VPWR VPWR _0311_ sky130_fd_sc_hd__nor2_1
XTAP_TAPCELL_ROW_31_263 VGND VPWR sky130_fd_sc_hd__tapvpwrvgnd_1
XFILLER_21_268 VGND VGND VPWR VPWR sky130_fd_sc_hd__fill_2
XFILLER_12_246 VGND VGND VPWR VPWR sky130_fd_sc_hd__decap_6
XFILLER_5_39 VPWR VGND VPWR VGND sky130_ef_sc_hd__decap_12
XFILLER_20_290 VGND VGND VPWR VPWR sky130_fd_sc_hd__fill_2
XFILLER_47_176 VGND VGND VPWR VPWR sky130_fd_sc_hd__fill_1
XTAP_TAPCELL_ROW_45_333 VGND VPWR sky130_fd_sc_hd__tapvpwrvgnd_1
XPHY_EDGE_ROW_7_Right_7 VGND VGND VPWR VPWR sky130_fd_sc_hd__decap_3
X_0545_ _0080_ min_counter_alarm.unit_m_alarm\[1\] VGND VGND VPWR VPWR _0100_ sky130_fd_sc_hd__nor2_1
X_0614_ _0155_ top_counter.second_counter.unit_s\[0\] top_counter.second_counter.unit_s\[1\]
+ VGND VGND VPWR VPWR _0164_ sky130_fd_sc_hd__or3b_1
X_1028_ min_counter_alarm.ten_m_alarm\[3\] _0449_ VGND VGND VPWR VPWR _0450_ sky130_fd_sc_hd__xnor2_1
XPHY_EDGE_ROW_12_Left_62 VGND VGND VPWR VPWR sky130_fd_sc_hd__decap_3
XFILLER_44_157 VGND VGND VPWR VPWR sky130_fd_sc_hd__decap_4
XFILLER_4_253 VPWR VGND VPWR VGND sky130_ef_sc_hd__decap_12
XFILLER_35_113 VPWR VGND VPWR VGND sky130_ef_sc_hd__decap_12
XFILLER_35_102 VGND VGND VPWR VPWR sky130_fd_sc_hd__decap_8
X_0528_ top_counter.second_counter.unit_s\[0\] VGND VGND VPWR VPWR _0083_ sky130_fd_sc_hd__inv_2
XFILLER_25_25 VGND VGND VPWR VPWR sky130_fd_sc_hd__decap_8
XFILLER_26_135 VGND VGND VPWR VPWR sky130_fd_sc_hd__decap_4
XFILLER_41_57 VGND VGND VPWR VPWR sky130_fd_sc_hd__decap_4
XFILLER_1_201 VGND VGND VPWR VPWR sky130_fd_sc_hd__decap_6
XFILLER_49_238 VGND VGND VPWR VPWR sky130_fd_sc_hd__decap_3
XFILLER_2_29 VGND VGND VPWR VPWR sky130_fd_sc_hd__fill_1
XFILLER_17_179 VGND VGND VPWR VPWR sky130_fd_sc_hd__fill_1
Xoutput90 net90 VGND VGND VPWR VPWR led_unit_s[2] sky130_fd_sc_hd__buf_2
XTAP_TAPCELL_ROW_18_196 VGND VPWR sky130_fd_sc_hd__tapvpwrvgnd_1
XFILLER_11_27 VPWR VGND VPWR VGND sky130_ef_sc_hd__decap_12
XFILLER_36_68 VPWR VGND VPWR VGND sky130_ef_sc_hd__decap_12
XTAP_TAPCELL_ROW_9_153 VGND VPWR sky130_fd_sc_hd__tapvpwrvgnd_1
X_0931_ net119 _0382_ _0340_ _0244_ VGND VGND VPWR VPWR _0384_ sky130_fd_sc_hd__o211ai_1
X_0862_ net114 net112 net104 net113 VGND VGND VPWR VPWR _0334_ sky130_fd_sc_hd__or4b_1
XFILLER_13_193 VGND VGND VPWR VPWR sky130_fd_sc_hd__decap_8
XFILLER_20_119 VGND VGND VPWR VPWR sky130_fd_sc_hd__fill_1
X_0793_ net123 ten_mo\[0\] VGND VGND VPWR VPWR _0288_ sky130_fd_sc_hd__and2b_1
Xfanout132 ten_d\[3\] VGND VGND VPWR VPWR net132 sky130_fd_sc_hd__buf_2
Xfanout121 top_counter.day_counter.unit_d\[1\] VGND VGND VPWR VPWR net121 sky130_fd_sc_hd__clkbuf_2
Xfanout143 net144 VGND VGND VPWR VPWR net143 sky130_fd_sc_hd__clkbuf_4
XFILLER_27_230 VPWR VGND VPWR VGND sky130_ef_sc_hd__decap_12
XTAP_TAPCELL_ROW_37_291 VGND VPWR sky130_fd_sc_hd__tapvpwrvgnd_1
XFILLER_10_141 VGND VGND VPWR VPWR sky130_fd_sc_hd__fill_1
XTAP_TAPCELL_ROW_12_169 VGND VPWR sky130_fd_sc_hd__tapvpwrvgnd_1
XPHY_EDGE_ROW_0_Left_50 VGND VGND VPWR VPWR sky130_fd_sc_hd__decap_3
XFILLER_6_178 VPWR VGND VPWR VGND sky130_ef_sc_hd__decap_12
X_1130_ net163 _0508_ _0514_ _0513_ VGND VGND VPWR VPWR _0068_ sky130_fd_sc_hd__a31o_1
XFILLER_26_7 VGND VGND VPWR VPWR sky130_fd_sc_hd__decap_6
X_1061_ top_counter.second_counter.unit_s\[2\] net165 _0469_ _0470_ _0468_ VGND VGND
+ VPWR VPWR _0043_ sky130_fd_sc_hd__a311oi_1
XFILLER_18_241 VGND VGND VPWR VPWR sky130_fd_sc_hd__decap_8
X_0845_ _0085_ net113 net112 VGND VGND VPWR VPWR _0321_ sky130_fd_sc_hd__a21oi_1
X_0914_ ten_h\[2\] ten_h\[3\] top_counter.hour_counter.unit_h\[0\] net118 VGND VGND
+ VPWR VPWR _0367_ sky130_fd_sc_hd__or4bb_1
X_0776_ net115 top_counter.min_counter.t2 net117 VGND VGND VPWR VPWR _0278_ sky130_fd_sc_hd__o21ai_1
XFILLER_33_69 VGND VGND VPWR VPWR sky130_fd_sc_hd__fill_2
XFILLER_24_266 VPWR VGND VPWR VGND sky130_ef_sc_hd__decap_12
XTAP_TAPCELL_ROW_26_239 VGND VPWR sky130_fd_sc_hd__tapvpwrvgnd_1
XPHY_EDGE_ROW_42_Left_92 VGND VGND VPWR VPWR sky130_fd_sc_hd__decap_3
X_0630_ top_counter.leap_year_check.u\[1\] top_counter.leap_year_check.u\[0\] VGND
+ VGND VPWR VPWR _0174_ sky130_fd_sc_hd__and2b_1
X_0561_ hour_counter_alarm.ten_h_alarm\[1\] ten_h\[1\] VGND VGND VPWR VPWR _0116_
+ sky130_fd_sc_hd__and2b_1
XTAP_TAPCELL_ROW_0_107 VGND VPWR sky130_fd_sc_hd__tapvpwrvgnd_1
X_1044_ _0455_ _0458_ ten_h\[0\] VGND VGND VPWR VPWR _0461_ sky130_fd_sc_hd__o21ai_1
X_1113_ _0477_ _0480_ VGND VGND VPWR VPWR _0503_ sky130_fd_sc_hd__nand2_1
X_0828_ net131 net130 VGND VGND VPWR VPWR _0310_ sky130_fd_sc_hd__nand2_1
XTAP_TAPCELL_ROW_31_264 VGND VPWR sky130_fd_sc_hd__tapvpwrvgnd_1
X_0759_ _0261_ _0266_ _0260_ VGND VGND VPWR VPWR _0268_ sky130_fd_sc_hd__a21o_1
XFILLER_28_25 VGND VGND VPWR VPWR sky130_fd_sc_hd__decap_3
XFILLER_28_47 VGND VGND VPWR VPWR sky130_fd_sc_hd__fill_1
XFILLER_12_236 VGND VGND VPWR VPWR sky130_fd_sc_hd__fill_1
XFILLER_47_144 VGND VGND VPWR VPWR sky130_fd_sc_hd__decap_8
XTAP_TAPCELL_ROW_45_334 VGND VPWR sky130_fd_sc_hd__tapvpwrvgnd_1
X_0613_ _0161_ _0162_ _0163_ VGND VGND VPWR VPWR net91 sky130_fd_sc_hd__a21o_1
X_0544_ top_counter.min_counter.u1 min_counter_alarm.unit_m_alarm\[1\] VGND VGND VPWR
+ VPWR _0099_ sky130_fd_sc_hd__and2b_1
Xclkbuf_3_5__f_clk clknet_0_clk VGND VGND VPWR VPWR clknet_3_5__leaf_clk sky130_fd_sc_hd__clkbuf_16
X_1027_ min_counter_alarm.ten_m_alarm\[2\] _0439_ _0445_ VGND VGND VPWR VPWR _0449_
+ sky130_fd_sc_hd__and3_1
XFILLER_39_79 VPWR VGND VPWR VGND sky130_ef_sc_hd__decap_12
XFILLER_39_57 VPWR VGND VPWR VGND sky130_ef_sc_hd__decap_12
XFILLER_29_111 VGND VGND VPWR VPWR sky130_fd_sc_hd__fill_1
XFILLER_44_169 VGND VGND VPWR VPWR sky130_fd_sc_hd__decap_8
XTAP_TAPCELL_ROW_42_315 VGND VPWR sky130_fd_sc_hd__tapvpwrvgnd_1
XFILLER_4_265 VPWR VGND VPWR VGND sky130_ef_sc_hd__decap_12
XFILLER_20_70 VPWR VGND VPWR VGND sky130_ef_sc_hd__decap_12
XFILLER_35_169 VPWR VGND VPWR VGND sky130_ef_sc_hd__decap_12
XFILLER_35_125 VPWR VGND VPWR VGND sky130_ef_sc_hd__decap_12
XFILLER_6_83 VGND VGND VPWR VPWR sky130_fd_sc_hd__fill_1
X_0527_ top_counter.min_counter.u3 VGND VGND VPWR VPWR _0082_ sky130_fd_sc_hd__inv_2
XFILLER_49_217 VGND VGND VPWR VPWR sky130_fd_sc_hd__decap_3
XFILLER_1_279 VGND VGND VPWR VPWR sky130_fd_sc_hd__fill_1
XFILLER_32_139 VGND VGND VPWR VPWR sky130_fd_sc_hd__fill_1
Xoutput80 net80 VGND VGND VPWR VPWR led_unit_m[6] sky130_fd_sc_hd__buf_2
Xoutput91 net91 VGND VGND VPWR VPWR led_unit_s[3] sky130_fd_sc_hd__buf_2
XTAP_TAPCELL_ROW_18_197 VGND VPWR sky130_fd_sc_hd__tapvpwrvgnd_1
XFILLER_31_161 VGND VGND VPWR VPWR sky130_fd_sc_hd__decap_6
XFILLER_11_39 VPWR VGND VPWR VGND sky130_ef_sc_hd__decap_12
XFILLER_14_139 VGND VGND VPWR VPWR sky130_fd_sc_hd__fill_1
XFILLER_22_172 VGND VGND VPWR VPWR sky130_fd_sc_hd__decap_8
XTAP_TAPCELL_ROW_9_154 VGND VPWR sky130_fd_sc_hd__tapvpwrvgnd_1
X_0792_ ten_mo\[0\] _0286_ _0287_ ten_mo\[2\] VGND VGND VPWR VPWR net41 sky130_fd_sc_hd__a22o_1
X_0930_ _0376_ _0379_ _0380_ _0382_ VGND VGND VPWR VPWR _0383_ sky130_fd_sc_hd__and4_1
X_0861_ _0324_ _0329_ _0332_ _0333_ VGND VGND VPWR VPWR net49 sky130_fd_sc_hd__a31o_1
XFILLER_47_3 VPWR VGND VPWR VGND sky130_ef_sc_hd__decap_12
XFILLER_36_253 VGND VGND VPWR VPWR sky130_fd_sc_hd__decap_3
XFILLER_22_27 VGND VGND VPWR VPWR sky130_fd_sc_hd__fill_1
Xfanout133 net134 VGND VGND VPWR VPWR net133 sky130_fd_sc_hd__buf_2
Xfanout122 top_counter.day_counter.unit_d\[0\] VGND VGND VPWR VPWR net122 sky130_fd_sc_hd__buf_2
XTAP_TAPCELL_ROW_6_135 VGND VPWR sky130_fd_sc_hd__tapvpwrvgnd_1
XFILLER_19_209 VPWR VGND VPWR VGND sky130_ef_sc_hd__decap_12
Xfanout144 net145 VGND VGND VPWR VPWR net144 sky130_fd_sc_hd__buf_2
XTAP_TAPCELL_ROW_37_292 VGND VPWR sky130_fd_sc_hd__tapvpwrvgnd_1
XFILLER_27_242 VGND VGND VPWR VPWR sky130_fd_sc_hd__fill_2
XPHY_EDGE_ROW_29_Right_29 VGND VGND VPWR VPWR sky130_fd_sc_hd__decap_3
XPHY_EDGE_ROW_38_Right_38 VGND VGND VPWR VPWR sky130_fd_sc_hd__decap_3
XFILLER_10_197 VGND VGND VPWR VPWR sky130_fd_sc_hd__decap_4
XPHY_EDGE_ROW_47_Right_47 VGND VGND VPWR VPWR sky130_fd_sc_hd__decap_3
X_1060_ top_counter.second_counter.unit_s\[2\] _0469_ top_counter.second_counter.unit_s\[3\]
+ VGND VGND VPWR VPWR _0470_ sky130_fd_sc_hd__a21oi_1
XFILLER_33_223 VGND VGND VPWR VPWR sky130_fd_sc_hd__fill_1
XFILLER_18_253 VGND VGND VPWR VPWR sky130_fd_sc_hd__decap_8
X_0775_ net117 _0277_ VGND VGND VPWR VPWR net34 sky130_fd_sc_hd__or2_1
X_0844_ net114 net113 ten_s\[3\] VGND VGND VPWR VPWR _0320_ sky130_fd_sc_hd__a21oi_1
X_0913_ top_counter.hour_counter.unit_h\[2\] top_counter.hour_counter.unit_h\[3\]
+ ten_h\[0\] _0073_ VGND VGND VPWR VPWR _0366_ sky130_fd_sc_hd__or4_1
X_1189_ clknet_3_2__leaf_clk _0050_ net139 VGND VGND VPWR VPWR hour_counter_alarm.ten_h_alarm\[2\]
+ sky130_fd_sc_hd__dfrtp_2
XFILLER_24_256 VGND VGND VPWR VPWR sky130_fd_sc_hd__fill_1
XFILLER_24_278 VPWR VGND VPWR VGND sky130_ef_sc_hd__decap_12
XFILLER_15_223 VGND VGND VPWR VPWR sky130_fd_sc_hd__fill_1
Xmax_cap108 net109 VGND VGND VPWR VPWR net108 sky130_fd_sc_hd__clkbuf_2
X_0560_ _0112_ _0113_ _0114_ _0111_ VGND VGND VPWR VPWR _0115_ sky130_fd_sc_hd__a211o_1
XTAP_TAPCELL_ROW_0_108 VGND VPWR sky130_fd_sc_hd__tapvpwrvgnd_1
XFILLER_0_85 VGND VGND VPWR VPWR sky130_fd_sc_hd__fill_2
X_1112_ _0477_ _0482_ VGND VGND VPWR VPWR _0502_ sky130_fd_sc_hd__nand2_1
X_1043_ _0454_ _0460_ _0459_ top_counter.hour_counter.unit_h\[3\] VGND VGND VPWR VPWR
+ _0035_ sky130_fd_sc_hd__o2bb2a_1
XFILLER_21_204 VGND VGND VPWR VPWR sky130_fd_sc_hd__decap_3
XFILLER_21_248 VPWR VGND VPWR VGND sky130_ef_sc_hd__decap_12
X_0827_ _0307_ _0309_ VGND VGND VPWR VPWR net53 sky130_fd_sc_hd__xnor2_1
X_0758_ _0265_ _0267_ VGND VGND VPWR VPWR net27 sky130_fd_sc_hd__or2_1
XFILLER_0_119 VGND VGND VPWR VPWR sky130_fd_sc_hd__decap_3
X_0689_ _0208_ net103 _0214_ VGND VGND VPWR VPWR _0215_ sky130_fd_sc_hd__o21ai_1
XFILLER_18_81 VGND VGND VPWR VPWR sky130_fd_sc_hd__decap_3
XFILLER_11_281 VPWR VGND VPWR VGND sky130_ef_sc_hd__decap_12
X_0612_ top_counter.second_counter.unit_s\[1\] _0155_ _0154_ VGND VGND VPWR VPWR _0163_
+ sky130_fd_sc_hd__o21a_1
X_0543_ top_counter.hour_counter.unit_h\[0\] net118 top_counter.hour_counter.unit_h\[2\]
+ top_counter.hour_counter.unit_h\[3\] VGND VGND VPWR VPWR _0098_ sky130_fd_sc_hd__nor4_1
X_1026_ _0444_ _0447_ _0448_ _0440_ min_counter_alarm.ten_m_alarm\[2\] VGND VGND VPWR
+ VPWR _0030_ sky130_fd_sc_hd__a32o_1
XFILLER_39_25 VGND VGND VPWR VPWR sky130_fd_sc_hd__decap_8
XFILLER_39_69 VGND VGND VPWR VPWR sky130_fd_sc_hd__fill_1
XFILLER_29_167 VGND VGND VPWR VPWR sky130_fd_sc_hd__fill_1
XFILLER_29_189 VGND VGND VPWR VPWR sky130_fd_sc_hd__fill_2
XTAP_TAPCELL_ROW_42_316 VGND VPWR sky130_fd_sc_hd__tapvpwrvgnd_1
XFILLER_4_222 VGND VGND VPWR VPWR sky130_fd_sc_hd__decap_4
XFILLER_4_277 VPWR VGND VPWR VGND sky130_ef_sc_hd__decap_12
XFILLER_20_82 VGND VGND VPWR VPWR sky130_fd_sc_hd__fill_2
XFILLER_35_137 VPWR VGND VPWR VGND sky130_ef_sc_hd__decap_12
XFILLER_43_181 VGND VGND VPWR VPWR sky130_fd_sc_hd__fill_1
X_0526_ net116 VGND VGND VPWR VPWR _0081_ sky130_fd_sc_hd__inv_2
X_1009_ net120 _0433_ VGND VGND VPWR VPWR _0026_ sky130_fd_sc_hd__xnor2_1
XFILLER_41_15 VGND VGND VPWR VPWR sky130_fd_sc_hd__decap_4
XFILLER_1_225 VGND VGND VPWR VPWR sky130_fd_sc_hd__decap_6
XFILLER_17_159 VGND VGND VPWR VPWR sky130_fd_sc_hd__decap_8
Xoutput70 net70 VGND VGND VPWR VPWR led_unit_h[3] sky130_fd_sc_hd__buf_2
XFILLER_48_295 VGND VGND VPWR VPWR sky130_fd_sc_hd__fill_1
Xoutput92 net92 VGND VGND VPWR VPWR led_unit_s[4] sky130_fd_sc_hd__buf_2
Xoutput81 net81 VGND VGND VPWR VPWR led_unit_mo[0] sky130_fd_sc_hd__buf_2
XTAP_TAPCELL_ROW_18_198 VGND VPWR sky130_fd_sc_hd__tapvpwrvgnd_1
XFILLER_7_3 VPWR VGND VPWR VGND sky130_ef_sc_hd__decap_12
XFILLER_26_81 VGND VGND VPWR VPWR sky130_fd_sc_hd__decap_3
X_0791_ net123 _0092_ VGND VGND VPWR VPWR _0287_ sky130_fd_sc_hd__nand2_1
X_0860_ net113 _0325_ _0326_ VGND VGND VPWR VPWR _0333_ sky130_fd_sc_hd__a21o_1
XFILLER_3_74 VPWR VGND VPWR VGND sky130_ef_sc_hd__decap_12
XFILLER_36_221 VPWR VGND VPWR VGND sky130_ef_sc_hd__decap_12
X_0989_ _0189_ _0290_ _0377_ VGND VGND VPWR VPWR _0425_ sky130_fd_sc_hd__o21ai_2
XFILLER_47_47 VGND VGND VPWR VPWR sky130_fd_sc_hd__decap_3
Xfanout134 ten_d\[2\] VGND VGND VPWR VPWR net134 sky130_fd_sc_hd__buf_1
Xfanout123 ten_mo\[1\] VGND VGND VPWR VPWR net123 sky130_fd_sc_hd__clkbuf_2
XTAP_TAPCELL_ROW_6_136 VGND VPWR sky130_fd_sc_hd__tapvpwrvgnd_1
Xfanout145 net3 VGND VGND VPWR VPWR net145 sky130_fd_sc_hd__buf_2
Xfanout112 ten_s\[2\] VGND VGND VPWR VPWR net112 sky130_fd_sc_hd__clkbuf_2
XTAP_TAPCELL_ROW_37_293 VGND VPWR sky130_fd_sc_hd__tapvpwrvgnd_1
XFILLER_37_91 VGND VGND VPWR VPWR sky130_fd_sc_hd__decap_8
XFILLER_37_80 VGND VGND VPWR VPWR sky130_fd_sc_hd__decap_4
XFILLER_18_210 VPWR VGND VPWR VGND sky130_ef_sc_hd__decap_12
XFILLER_18_232 VGND VGND VPWR VPWR sky130_fd_sc_hd__fill_1
XFILLER_18_276 VGND VGND VPWR VPWR sky130_fd_sc_hd__fill_2
XFILLER_33_279 VGND VGND VPWR VPWR sky130_fd_sc_hd__fill_1
X_0912_ net1 control_unit.select_time\[3\] VGND VGND VPWR VPWR _0365_ sky130_fd_sc_hd__and2_1
X_0843_ net130 _0308_ _0315_ net131 VGND VGND VPWR VPWR net58 sky130_fd_sc_hd__o31a_1
X_0774_ net115 top_counter.min_counter.t2 VGND VGND VPWR VPWR _0277_ sky130_fd_sc_hd__and2b_1
XTAP_TAPCELL_ROW_11_160 VGND VPWR sky130_fd_sc_hd__tapvpwrvgnd_1
X_1188_ clknet_3_3__leaf_clk _0049_ net140 VGND VGND VPWR VPWR hour_counter_alarm.ten_h_alarm\[1\]
+ sky130_fd_sc_hd__dfrtp_2
XFILLER_17_39 VGND VGND VPWR VPWR sky130_fd_sc_hd__fill_1
XFILLER_24_213 VGND VGND VPWR VPWR sky130_fd_sc_hd__fill_1
XFILLER_3_139 VGND VGND VPWR VPWR sky130_fd_sc_hd__fill_1
XFILLER_15_246 VGND VGND VPWR VPWR sky130_fd_sc_hd__decap_8
XFILLER_15_279 VGND VGND VPWR VPWR sky130_fd_sc_hd__fill_1
XTAP_TAPCELL_ROW_25_230 VGND VPWR sky130_fd_sc_hd__tapvpwrvgnd_1
Xmax_cap109 net5 VGND VGND VPWR VPWR net109 sky130_fd_sc_hd__clkbuf_2
XPHY_EDGE_ROW_29_Left_79 VGND VGND VPWR VPWR sky130_fd_sc_hd__decap_3
XFILLER_31_7 VPWR VGND VPWR VGND sky130_ef_sc_hd__decap_12
XFILLER_2_194 VGND VGND VPWR VPWR sky130_fd_sc_hd__fill_2
XTAP_TAPCELL_ROW_0_109 VGND VPWR sky130_fd_sc_hd__tapvpwrvgnd_1
XFILLER_0_42 VGND VGND VPWR VPWR sky130_fd_sc_hd__decap_3
XFILLER_0_97 VGND VGND VPWR VPWR sky130_fd_sc_hd__decap_4
X_1111_ hour_counter_alarm.unit_h_alarm\[0\] _0477_ hour_counter_alarm.unit_h_alarm\[1\]
+ VGND VGND VPWR VPWR _0501_ sky130_fd_sc_hd__a21o_1
X_1042_ _0458_ _0460_ VGND VGND VPWR VPWR _0034_ sky130_fd_sc_hd__nor2_1
X_0826_ net131 _0308_ VGND VGND VPWR VPWR _0309_ sky130_fd_sc_hd__nor2_1
X_0757_ ten_h\[0\] _0259_ _0255_ VGND VGND VPWR VPWR _0267_ sky130_fd_sc_hd__o21a_1
X_0688_ _0213_ hour_counter_alarm.unit_h_alarm\[0\] net109 VGND VGND VPWR VPWR _0214_
+ sky130_fd_sc_hd__mux2_1
XTAP_TAPCELL_ROW_39_300 VGND VPWR sky130_fd_sc_hd__tapvpwrvgnd_1
XFILLER_44_15 VPWR VGND VPWR VGND sky130_ef_sc_hd__decap_12
XFILLER_8_209 VGND VGND VPWR VPWR sky130_fd_sc_hd__fill_1
XFILLER_12_216 VPWR VGND VPWR VGND sky130_ef_sc_hd__decap_12
XFILLER_47_113 VGND VGND VPWR VPWR sky130_fd_sc_hd__fill_2
XFILLER_7_220 VGND VGND VPWR VPWR sky130_fd_sc_hd__decap_4
XFILLER_7_264 VPWR VGND VPWR VGND sky130_ef_sc_hd__decap_12
X_0542_ control_unit.mode_display\[0\] VGND VGND VPWR VPWR _0097_ sky130_fd_sc_hd__inv_2
X_0611_ _0154_ _0159_ VGND VGND VPWR VPWR _0162_ sky130_fd_sc_hd__and2b_1
XFILLER_38_135 VGND VGND VPWR VPWR sky130_fd_sc_hd__decap_4
XFILLER_38_113 VGND VGND VPWR VPWR sky130_fd_sc_hd__fill_2
X_1025_ min_counter_alarm.ten_m_alarm\[2\] _0445_ VGND VGND VPWR VPWR _0448_ sky130_fd_sc_hd__or2_1
XFILLER_14_29 VGND VGND VPWR VPWR sky130_fd_sc_hd__decap_4
X_0809_ _0095_ hun_y\[3\] _0297_ VGND VGND VPWR VPWR _0298_ sky130_fd_sc_hd__o21ai_1
XFILLER_29_113 VPWR VGND VPWR VGND sky130_ef_sc_hd__decap_12
XTAP_TAPCELL_ROW_42_317 VGND VPWR sky130_fd_sc_hd__tapvpwrvgnd_1
XFILLER_4_289 VGND VGND VPWR VPWR sky130_fd_sc_hd__decap_6
XFILLER_35_149 VPWR VGND VPWR VGND sky130_ef_sc_hd__decap_12
X_0525_ top_counter.min_counter.u1 VGND VGND VPWR VPWR _0080_ sky130_fd_sc_hd__inv_2
XPHY_EDGE_ROW_16_Left_66 VGND VGND VPWR VPWR sky130_fd_sc_hd__decap_3
X_1008_ top_counter.day_counter.unit_d\[0\] net121 net120 _0370_ VGND VGND VPWR VPWR
+ _0435_ sky130_fd_sc_hd__and4_1
XFILLER_40_141 VGND VGND VPWR VPWR sky130_fd_sc_hd__fill_1
Xoutput60 net60 VGND VGND VPWR VPWR led_unit_d[0] sky130_fd_sc_hd__buf_2
Xoutput93 net93 VGND VGND VPWR VPWR led_unit_s[5] sky130_fd_sc_hd__buf_2
Xoutput82 net82 VGND VGND VPWR VPWR led_unit_mo[1] sky130_fd_sc_hd__buf_2
Xoutput71 net71 VGND VGND VPWR VPWR led_unit_h[4] sky130_fd_sc_hd__buf_2
XFILLER_48_241 VGND VGND VPWR VPWR sky130_fd_sc_hd__decap_8
XFILLER_0_281 VPWR VGND VPWR VGND sky130_ef_sc_hd__decap_12
XTAP_TAPCELL_ROW_18_199 VGND VPWR sky130_fd_sc_hd__tapvpwrvgnd_1
XFILLER_22_141 VPWR VGND VPWR VGND sky130_ef_sc_hd__decap_12
XFILLER_22_163 VGND VGND VPWR VPWR sky130_fd_sc_hd__decap_4
XFILLER_45_222 VGND VGND VPWR VPWR sky130_fd_sc_hd__fill_2
XFILLER_45_277 VGND VGND VPWR VPWR sky130_fd_sc_hd__decap_3
X_0790_ net123 ten_mo\[3\] VGND VGND VPWR VPWR _0286_ sky130_fd_sc_hd__nand2_1
XFILLER_9_167 VGND VGND VPWR VPWR sky130_fd_sc_hd__fill_1
XFILLER_9_178 VPWR VGND VPWR VGND sky130_ef_sc_hd__decap_12
XFILLER_3_86 VGND VGND VPWR VPWR sky130_fd_sc_hd__decap_4
XFILLER_36_233 VPWR VGND VPWR VGND sky130_ef_sc_hd__decap_12
XFILLER_22_29 VPWR VGND VPWR VGND sky130_ef_sc_hd__decap_12
X_0988_ net127 _0423_ net126 VGND VGND VPWR VPWR _0424_ sky130_fd_sc_hd__a21o_1
Xfanout102 _0402_ VGND VGND VPWR VPWR net102 sky130_fd_sc_hd__clkbuf_4
Xfanout113 ten_s\[1\] VGND VGND VPWR VPWR net113 sky130_fd_sc_hd__clkbuf_2
XFILLER_47_15 VPWR VGND VPWR VGND sky130_ef_sc_hd__decap_12
Xfanout135 ten_d\[1\] VGND VGND VPWR VPWR net135 sky130_fd_sc_hd__clkbuf_2
Xfanout124 top_counter.day_in_month_decode.unit_mo\[3\] VGND VGND VPWR VPWR net124
+ sky130_fd_sc_hd__buf_2
XTAP_TAPCELL_ROW_6_137 VGND VPWR sky130_fd_sc_hd__tapvpwrvgnd_1
XFILLER_27_222 VGND VGND VPWR VPWR sky130_fd_sc_hd__fill_2
XTAP_TAPCELL_ROW_37_294 VGND VPWR sky130_fd_sc_hd__tapvpwrvgnd_1
XFILLER_33_225 VPWR VGND VPWR VGND sky130_ef_sc_hd__decap_12
XFILLER_18_222 VGND VGND VPWR VPWR sky130_fd_sc_hd__decap_4
X_0842_ _0308_ _0315_ VGND VGND VPWR VPWR _0319_ sky130_fd_sc_hd__nor2_1
XFILLER_41_291 VGND VGND VPWR VPWR sky130_fd_sc_hd__fill_1
X_0911_ top_counter.min_counter.t2 _0279_ _0364_ VGND VGND VPWR VPWR top_counter.min_counter.d_t2
+ sky130_fd_sc_hd__mux2_1
XFILLER_5_181 VPWR VGND VPWR VGND sky130_ef_sc_hd__decap_12
X_0773_ top_counter.min_counter.t2 _0276_ _0273_ VGND VGND VPWR VPWR net33 sky130_fd_sc_hd__o21ai_1
XTAP_TAPCELL_ROW_11_161 VGND VPWR sky130_fd_sc_hd__tapvpwrvgnd_1
XTAP_TAPCELL_ROW_34_275 VGND VPWR sky130_fd_sc_hd__tapvpwrvgnd_1
X_1187_ clknet_3_3__leaf_clk _0048_ net140 VGND VGND VPWR VPWR hour_counter_alarm.ten_h_alarm\[0\]
+ sky130_fd_sc_hd__dfrtp_1
XPHY_EDGE_ROW_4_Left_54 VGND VGND VPWR VPWR sky130_fd_sc_hd__decap_3
XTAP_TAPCELL_ROW_25_231 VGND VPWR sky130_fd_sc_hd__tapvpwrvgnd_1
X_1110_ _0500_ _0478_ hour_counter_alarm.unit_h_alarm\[0\] VGND VGND VPWR VPWR _0062_
+ sky130_fd_sc_hd__mux2_1
XFILLER_24_7 VGND VGND VPWR VPWR sky130_fd_sc_hd__decap_3
XTAP_TAPCELL_ROW_48_345 VGND VPWR sky130_fd_sc_hd__tapvpwrvgnd_1
X_1041_ _0071_ _0456_ VGND VGND VPWR VPWR _0460_ sky130_fd_sc_hd__xnor2_1
X_0825_ _0088_ ten_y\[1\] VGND VGND VPWR VPWR _0308_ sky130_fd_sc_hd__and2_1
X_0756_ ten_h\[0\] _0253_ _0254_ VGND VGND VPWR VPWR _0266_ sky130_fd_sc_hd__nand3_1
X_0687_ _0207_ _0212_ VGND VGND VPWR VPWR _0213_ sky130_fd_sc_hd__nand2_1
XPHY_EDGE_ROW_46_Left_96 VGND VGND VPWR VPWR sky130_fd_sc_hd__decap_3
XTAP_TAPCELL_ROW_39_301 VGND VPWR sky130_fd_sc_hd__tapvpwrvgnd_1
XFILLER_44_49 VPWR VGND VPWR VGND sky130_ef_sc_hd__decap_12
XFILLER_44_27 VGND VGND VPWR VPWR sky130_fd_sc_hd__fill_1
XFILLER_12_228 VGND VGND VPWR VPWR sky130_fd_sc_hd__decap_8
XFILLER_47_103 VGND VGND VPWR VPWR sky130_fd_sc_hd__fill_1
XFILLER_47_158 VGND VGND VPWR VPWR sky130_fd_sc_hd__decap_3
XFILLER_34_82 VGND VGND VPWR VPWR sky130_fd_sc_hd__fill_2
X_0541_ hun_y\[2\] VGND VGND VPWR VPWR _0096_ sky130_fd_sc_hd__inv_2
XFILLER_7_276 VGND VGND VPWR VPWR sky130_fd_sc_hd__decap_4
X_0610_ _0138_ _0157_ VGND VGND VPWR VPWR _0161_ sky130_fd_sc_hd__nand2b_1
X_1024_ min_counter_alarm.ten_m_alarm\[2\] _0445_ VGND VGND VPWR VPWR _0447_ sky130_fd_sc_hd__nand2_1
X_0808_ hun_y\[3\] hun_y\[1\] VGND VGND VPWR VPWR _0297_ sky130_fd_sc_hd__nand2b_1
X_0739_ net105 _0250_ ten_h\[3\] VGND VGND VPWR VPWR _0251_ sky130_fd_sc_hd__nor3b_1
XFILLER_29_125 VPWR VGND VPWR VGND sky130_ef_sc_hd__decap_12
XFILLER_44_139 VGND VGND VPWR VPWR sky130_fd_sc_hd__fill_1
XTAP_TAPCELL_ROW_42_318 VGND VPWR sky130_fd_sc_hd__tapvpwrvgnd_1
XFILLER_29_169 VPWR VGND VPWR VGND sky130_ef_sc_hd__decap_12
X_0524_ top_counter.min_counter.c0 VGND VGND VPWR VPWR _0079_ sky130_fd_sc_hd__inv_2
X_1007_ _0394_ _0433_ _0434_ VGND VGND VPWR VPWR _0025_ sky130_fd_sc_hd__and3_1
XFILLER_26_139 VGND VGND VPWR VPWR sky130_fd_sc_hd__fill_1
XFILLER_1_216 VGND VGND VPWR VPWR sky130_fd_sc_hd__decap_8
XFILLER_32_109 VPWR VGND VPWR VGND sky130_ef_sc_hd__decap_12
XFILLER_40_197 VPWR VGND VPWR VGND sky130_ef_sc_hd__decap_12
XPHY_EDGE_ROW_33_Left_83 VGND VGND VPWR VPWR sky130_fd_sc_hd__decap_3
Xoutput61 net61 VGND VGND VPWR VPWR led_unit_d[1] sky130_fd_sc_hd__buf_2
Xoutput72 net72 VGND VGND VPWR VPWR led_unit_h[5] sky130_fd_sc_hd__buf_2
Xoutput50 net50 VGND VGND VPWR VPWR led_ten_s[4] sky130_fd_sc_hd__buf_2
Xoutput94 net94 VGND VGND VPWR VPWR led_unit_s[6] sky130_fd_sc_hd__buf_2
Xoutput83 net83 VGND VGND VPWR VPWR led_unit_mo[2] sky130_fd_sc_hd__buf_2
XFILLER_48_253 VPWR VGND VPWR VGND sky130_ef_sc_hd__decap_12
XFILLER_0_293 VGND VGND VPWR VPWR sky130_fd_sc_hd__decap_3
XFILLER_39_275 VGND VGND VPWR VPWR sky130_fd_sc_hd__fill_1
XFILLER_22_153 VGND VGND VPWR VPWR sky130_fd_sc_hd__decap_4
XFILLER_45_201 VGND VGND VPWR VPWR sky130_fd_sc_hd__fill_2
XFILLER_9_113 VPWR VGND VPWR VGND sky130_ef_sc_hd__decap_12
XFILLER_42_82 VGND VGND VPWR VPWR sky130_fd_sc_hd__fill_2
XFILLER_36_245 VGND VGND VPWR VPWR sky130_fd_sc_hd__decap_6
XFILLER_8_190 VGND VGND VPWR VPWR sky130_fd_sc_hd__decap_6
XFILLER_22_19 VGND VGND VPWR VPWR sky130_fd_sc_hd__decap_8
X_0987_ _0089_ _0423_ VGND VGND VPWR VPWR _0016_ sky130_fd_sc_hd__xnor2_1
Xfanout125 top_counter.day_in_month_decode.unit_mo\[2\] VGND VGND VPWR VPWR net125
+ sky130_fd_sc_hd__clkbuf_2
Xfanout136 net138 VGND VGND VPWR VPWR net136 sky130_fd_sc_hd__clkbuf_4
XTAP_TAPCELL_ROW_6_138 VGND VPWR sky130_fd_sc_hd__tapvpwrvgnd_1
Xfanout114 ten_s\[0\] VGND VGND VPWR VPWR net114 sky130_fd_sc_hd__clkbuf_2
XFILLER_47_27 VPWR VGND VPWR VGND sky130_ef_sc_hd__decap_12
XFILLER_42_226 VPWR VGND VPWR VGND sky130_ef_sc_hd__decap_12
XFILLER_10_156 VGND VGND VPWR VPWR sky130_fd_sc_hd__fill_2
XFILLER_10_189 VGND VGND VPWR VPWR sky130_fd_sc_hd__decap_6
XFILLER_12_52 VPWR VGND VPWR VGND sky130_ef_sc_hd__decap_12
XFILLER_12_85 VPWR VGND VPWR VGND sky130_ef_sc_hd__decap_12
XFILLER_33_237 VPWR VGND VPWR VGND sky130_ef_sc_hd__decap_12
XPHY_EDGE_ROW_16_Right_16 VGND VGND VPWR VPWR sky130_fd_sc_hd__decap_3
XFILLER_18_289 VGND VGND VPWR VPWR sky130_fd_sc_hd__decap_3
X_0841_ _0308_ _0316_ _0318_ net130 VGND VGND VPWR VPWR net57 sky130_fd_sc_hd__a22o_1
X_0910_ _0278_ _0361_ _0364_ net115 VGND VGND VPWR VPWR top_counter.min_counter.d_t1
+ sky130_fd_sc_hd__o22a_1
X_0772_ net117 net115 VGND VGND VPWR VPWR _0276_ sky130_fd_sc_hd__nor2_1
XTAP_TAPCELL_ROW_11_162 VGND VPWR sky130_fd_sc_hd__tapvpwrvgnd_1
XPHY_EDGE_ROW_25_Right_25 VGND VGND VPWR VPWR sky130_fd_sc_hd__decap_3
XFILLER_45_3 VPWR VGND VPWR VGND sky130_ef_sc_hd__decap_12
XFILLER_5_193 VGND VGND VPWR VPWR sky130_fd_sc_hd__decap_3
XPHY_EDGE_ROW_34_Right_34 VGND VGND VPWR VPWR sky130_fd_sc_hd__decap_3
X_1186_ clknet_3_0__leaf_clk _0047_ net136 VGND VGND VPWR VPWR ten_s\[3\] sky130_fd_sc_hd__dfrtp_2
XTAP_TAPCELL_ROW_34_276 VGND VPWR sky130_fd_sc_hd__tapvpwrvgnd_1
XFILLER_32_281 VGND VGND VPWR VPWR sky130_fd_sc_hd__decap_8
XPHY_EDGE_ROW_20_Left_70 VGND VGND VPWR VPWR sky130_fd_sc_hd__decap_3
XPHY_EDGE_ROW_43_Right_43 VGND VGND VPWR VPWR sky130_fd_sc_hd__decap_3
XTAP_TAPCELL_ROW_25_232 VGND VPWR sky130_fd_sc_hd__tapvpwrvgnd_1
XFILLER_23_51 VGND VGND VPWR VPWR sky130_fd_sc_hd__decap_4
XFILLER_23_95 VGND VGND VPWR VPWR sky130_fd_sc_hd__decap_6
XFILLER_23_281 VPWR VGND VPWR VGND sky130_ef_sc_hd__decap_12
XFILLER_2_152 VGND VGND VPWR VPWR sky130_fd_sc_hd__fill_1
XTAP_TAPCELL_ROW_48_346 VGND VPWR sky130_fd_sc_hd__tapvpwrvgnd_1
XFILLER_17_7 VGND VGND VPWR VPWR sky130_fd_sc_hd__decap_3
X_1040_ _0071_ _0456_ VGND VGND VPWR VPWR _0459_ sky130_fd_sc_hd__nor2_1
XFILLER_0_77 VGND VGND VPWR VPWR sky130_fd_sc_hd__decap_3
X_0824_ ten_y\[3\] _0306_ VGND VGND VPWR VPWR _0307_ sky130_fd_sc_hd__nor2_1
X_0755_ _0256_ _0260_ _0263_ _0265_ VGND VGND VPWR VPWR net26 sky130_fd_sc_hd__o22a_1
X_0686_ top_counter.hour_counter.unit_h\[0\] _0206_ VGND VGND VPWR VPWR _0212_ sky130_fd_sc_hd__nand2_1
XFILLER_28_29 VPWR VGND VPWR VGND sky130_ef_sc_hd__decap_12
XTAP_TAPCELL_ROW_39_302 VGND VPWR sky130_fd_sc_hd__tapvpwrvgnd_1
X_1169_ clknet_3_3__leaf_clk _0037_ net140 VGND VGND VPWR VPWR ten_h\[1\] sky130_fd_sc_hd__dfrtp_2
XFILLER_20_251 VGND VGND VPWR VPWR sky130_fd_sc_hd__fill_1
Xclkbuf_3_0__f_clk clknet_0_clk VGND VGND VPWR VPWR clknet_3_0__leaf_clk sky130_fd_sc_hd__clkbuf_16
XFILLER_34_61 VGND VGND VPWR VPWR sky130_fd_sc_hd__fill_2
X_0540_ hun_y\[0\] VGND VGND VPWR VPWR _0095_ sky130_fd_sc_hd__inv_2
X_1023_ _0445_ _0446_ min_counter_alarm.ten_m_alarm\[1\] _0440_ VGND VGND VPWR VPWR
+ _0029_ sky130_fd_sc_hd__a2bb2o_1
X_0807_ _0294_ _0296_ VGND VGND VPWR VPWR net11 sky130_fd_sc_hd__xor2_1
X_0738_ ten_h\[2\] _0249_ VGND VGND VPWR VPWR _0250_ sky130_fd_sc_hd__nor2_1
X_0669_ top_counter.min_counter.u1 top_counter.min_counter.u3 VGND VGND VPWR VPWR
+ _0200_ sky130_fd_sc_hd__nand2_1
XPHY_EDGE_ROW_2_Right_2 VGND VGND VPWR VPWR sky130_fd_sc_hd__decap_3
XFILLER_29_137 VPWR VGND VPWR VGND sky130_ef_sc_hd__decap_12
XTAP_TAPCELL_ROW_42_319 VGND VPWR sky130_fd_sc_hd__tapvpwrvgnd_1
XFILLER_37_181 VGND VGND VPWR VPWR sky130_fd_sc_hd__decap_8
XFILLER_4_247 VGND VGND VPWR VPWR sky130_fd_sc_hd__decap_4
XFILLER_29_83 VGND VGND VPWR VPWR sky130_fd_sc_hd__decap_4
XFILLER_6_65 VPWR VGND VPWR VGND sky130_ef_sc_hd__decap_12
XFILLER_6_43 VGND VGND VPWR VPWR sky130_fd_sc_hd__decap_4
X_0523_ min_counter_alarm.ten_m_alarm\[1\] VGND VGND VPWR VPWR _0078_ sky130_fd_sc_hd__inv_2
X_1006_ net122 _0370_ net121 VGND VGND VPWR VPWR _0434_ sky130_fd_sc_hd__a21o_1
XFILLER_34_195 VGND VGND VPWR VPWR sky130_fd_sc_hd__fill_1
XFILLER_40_121 VPWR VGND VPWR VGND sky130_ef_sc_hd__decap_12
XFILLER_31_62 VGND VGND VPWR VPWR sky130_fd_sc_hd__fill_2
Xoutput5 net109 VGND VGND VPWR VPWR alarm sky130_fd_sc_hd__buf_1
Xoutput95 net95 VGND VGND VPWR VPWR led_unit_y[0] sky130_fd_sc_hd__buf_2
Xoutput62 net62 VGND VGND VPWR VPWR led_unit_d[2] sky130_fd_sc_hd__buf_2
Xoutput40 net40 VGND VGND VPWR VPWR led_ten_mo[1] sky130_fd_sc_hd__buf_2
Xoutput73 net73 VGND VGND VPWR VPWR led_unit_h[6] sky130_fd_sc_hd__buf_2
XFILLER_0_250 VGND VGND VPWR VPWR sky130_fd_sc_hd__fill_2
Xoutput51 net51 VGND VGND VPWR VPWR led_ten_s[5] sky130_fd_sc_hd__buf_2
Xoutput84 net84 VGND VGND VPWR VPWR led_unit_mo[3] sky130_fd_sc_hd__buf_2
XFILLER_48_265 VPWR VGND VPWR VGND sky130_ef_sc_hd__decap_12
XFILLER_31_187 VGND VGND VPWR VPWR sky130_fd_sc_hd__fill_1
XFILLER_39_243 VGND VGND VPWR VPWR sky130_fd_sc_hd__fill_1
XFILLER_36_29 VPWR VGND VPWR VGND sky130_ef_sc_hd__decap_12
XTAP_TAPCELL_ROW_17_190 VGND VPWR sky130_fd_sc_hd__tapvpwrvgnd_1
XFILLER_26_73 VGND VGND VPWR VPWR sky130_fd_sc_hd__decap_8
XFILLER_9_125 VPWR VGND VPWR VGND sky130_ef_sc_hd__decap_12
XFILLER_9_169 VGND VGND VPWR VPWR sky130_fd_sc_hd__decap_3
XFILLER_36_279 VPWR VGND VPWR VGND sky130_ef_sc_hd__decap_12
X_0986_ net1 control_unit.select_time\[4\] _0399_ VGND VGND VPWR VPWR _0423_ sky130_fd_sc_hd__a21bo_2
Xfanout115 top_counter.min_counter.t1 VGND VGND VPWR VPWR net115 sky130_fd_sc_hd__buf_2
XTAP_TAPCELL_ROW_6_139 VGND VPWR sky130_fd_sc_hd__tapvpwrvgnd_1
Xfanout104 _0153_ VGND VGND VPWR VPWR net104 sky130_fd_sc_hd__buf_2
Xfanout137 net138 VGND VGND VPWR VPWR net137 sky130_fd_sc_hd__clkbuf_4
Xfanout126 top_counter.day_in_month_decode.unit_mo\[1\] VGND VGND VPWR VPWR net126
+ sky130_fd_sc_hd__buf_2
XFILLER_47_39 VGND VGND VPWR VPWR sky130_fd_sc_hd__decap_8
XFILLER_27_202 VGND VGND VPWR VPWR sky130_fd_sc_hd__decap_6
XFILLER_27_279 VGND VGND VPWR VPWR sky130_fd_sc_hd__fill_1
XFILLER_42_238 VPWR VGND VPWR VGND sky130_ef_sc_hd__decap_12
XFILLER_10_168 VGND VGND VPWR VPWR sky130_fd_sc_hd__decap_4
XFILLER_5_3 VPWR VGND VPWR VGND sky130_ef_sc_hd__decap_12
XFILLER_10_179 VGND VGND VPWR VPWR sky130_fd_sc_hd__decap_4
XFILLER_12_64 VPWR VGND VPWR VGND sky130_ef_sc_hd__decap_12
XFILLER_12_97 VGND VGND VPWR VPWR sky130_fd_sc_hd__decap_4
XFILLER_33_249 VPWR VGND VPWR VGND sky130_ef_sc_hd__decap_12
XFILLER_33_205 VPWR VGND VPWR VGND sky130_ef_sc_hd__decap_12
X_0840_ net131 _0306_ VGND VGND VPWR VPWR _0318_ sky130_fd_sc_hd__or2_1
X_0771_ _0275_ VGND VGND VPWR VPWR net32 sky130_fd_sc_hd__inv_2
XTAP_TAPCELL_ROW_11_163 VGND VPWR sky130_fd_sc_hd__tapvpwrvgnd_1
XFILLER_38_3 VGND VGND VPWR VPWR sky130_fd_sc_hd__decap_3
X_1185_ clknet_3_0__leaf_clk _0046_ net136 VGND VGND VPWR VPWR ten_s\[2\] sky130_fd_sc_hd__dfrtp_1
XFILLER_24_227 VGND VGND VPWR VPWR sky130_fd_sc_hd__fill_2
XTAP_TAPCELL_ROW_34_277 VGND VPWR sky130_fd_sc_hd__tapvpwrvgnd_1
XFILLER_33_19 VPWR VGND VPWR VGND sky130_ef_sc_hd__decap_12
X_0969_ ten_y\[0\] top_counter.leap_year_check.u\[0\] VGND VGND VPWR VPWR _0414_ sky130_fd_sc_hd__and2b_1
XTAP_TAPCELL_ROW_25_233 VGND VPWR sky130_fd_sc_hd__tapvpwrvgnd_1
XFILLER_23_293 VGND VGND VPWR VPWR sky130_fd_sc_hd__decap_3
XFILLER_2_197 VGND VGND VPWR VPWR sky130_fd_sc_hd__decap_3
XTAP_TAPCELL_ROW_48_347 VGND VPWR sky130_fd_sc_hd__tapvpwrvgnd_1
XFILLER_48_71 VGND VGND VPWR VPWR sky130_fd_sc_hd__decap_4
XFILLER_48_60 VGND VGND VPWR VPWR sky130_fd_sc_hd__decap_6
X_0823_ ten_y\[0\] ten_y\[1\] VGND VGND VPWR VPWR _0306_ sky130_fd_sc_hd__and2_1
X_0754_ _0252_ _0260_ _0264_ VGND VGND VPWR VPWR _0265_ sky130_fd_sc_hd__o21ai_1
X_0685_ _0208_ net103 VGND VGND VPWR VPWR _0211_ sky130_fd_sc_hd__or2_1
XTAP_TAPCELL_ROW_39_303 VGND VPWR sky130_fd_sc_hd__tapvpwrvgnd_1
XFILLER_44_29 VPWR VGND VPWR VGND sky130_ef_sc_hd__decap_12
X_1099_ min_counter_alarm.unit_m_alarm\[3\] _0496_ VGND VGND VPWR VPWR _0497_ sky130_fd_sc_hd__xor2_1
X_1168_ clknet_3_3__leaf_clk _0036_ net140 VGND VGND VPWR VPWR ten_h\[0\] sky130_fd_sc_hd__dfrtp_4
X_1022_ min_counter_alarm.ten_m_alarm\[0\] min_counter_alarm.ten_m_alarm\[1\] _0444_
+ VGND VGND VPWR VPWR _0446_ sky130_fd_sc_hd__o21ai_1
X_0806_ hun_y\[3\] _0295_ VGND VGND VPWR VPWR _0296_ sky130_fd_sc_hd__nor2_1
X_0668_ _0082_ _0198_ _0199_ _0195_ VGND VGND VPWR VPWR net75 sky130_fd_sc_hd__a31o_1
X_0737_ ten_h\[1\] _0206_ VGND VGND VPWR VPWR _0249_ sky130_fd_sc_hd__or2_1
X_0599_ _0147_ _0148_ _0152_ VGND VGND VPWR VPWR _0153_ sky130_fd_sc_hd__nor3_2
XFILLER_29_149 VPWR VGND VPWR VGND sky130_ef_sc_hd__decap_12
XFILLER_20_97 VGND VGND VPWR VPWR sky130_fd_sc_hd__fill_1
XFILLER_43_141 VPWR VGND VPWR VGND sky130_ef_sc_hd__decap_12
XFILLER_6_77 VGND VGND VPWR VPWR sky130_fd_sc_hd__decap_6
XFILLER_3_281 VPWR VGND VPWR VGND sky130_ef_sc_hd__decap_12
X_0522_ hour_counter_alarm.unit_h_alarm\[3\] VGND VGND VPWR VPWR _0077_ sky130_fd_sc_hd__inv_2
X_1005_ top_counter.day_counter.unit_d\[0\] net121 _0370_ VGND VGND VPWR VPWR _0433_
+ sky130_fd_sc_hd__nand3_1
XFILLER_34_141 VPWR VGND VPWR VGND sky130_ef_sc_hd__decap_12
XFILLER_19_160 VGND VGND VPWR VPWR sky130_fd_sc_hd__fill_2
XFILLER_41_19 VGND VGND VPWR VPWR sky130_fd_sc_hd__fill_1
XFILLER_1_207 VGND VGND VPWR VPWR sky130_fd_sc_hd__fill_1
XFILLER_40_133 VGND VGND VPWR VPWR sky130_fd_sc_hd__decap_6
Xoutput41 net41 VGND VGND VPWR VPWR led_ten_mo[2] sky130_fd_sc_hd__buf_2
Xoutput6 net6 VGND VGND VPWR VPWR led_am_pm[0] sky130_fd_sc_hd__buf_1
Xoutput52 net52 VGND VGND VPWR VPWR led_ten_s[6] sky130_fd_sc_hd__buf_2
Xoutput30 net30 VGND VGND VPWR VPWR led_ten_h[5] sky130_fd_sc_hd__buf_2
Xoutput96 net96 VGND VGND VPWR VPWR led_unit_y[1] sky130_fd_sc_hd__buf_2
Xoutput63 net63 VGND VGND VPWR VPWR led_unit_d[3] sky130_fd_sc_hd__buf_2
XFILLER_48_277 VPWR VGND VPWR VGND sky130_ef_sc_hd__decap_12
XFILLER_48_222 VGND VGND VPWR VPWR sky130_fd_sc_hd__fill_1
Xoutput85 net85 VGND VGND VPWR VPWR led_unit_mo[4] sky130_fd_sc_hd__buf_2
Xoutput74 net74 VGND VGND VPWR VPWR led_unit_m[0] sky130_fd_sc_hd__buf_2
XFILLER_16_152 VGND VGND VPWR VPWR sky130_fd_sc_hd__decap_3
.ends
